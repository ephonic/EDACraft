//  **************************************************************
//  *  TSMC SPICE MODEL --- Security B - TSMC Restricted Secret  *
//  **************************************************************
section pre_simu
setscale options scalefactor=0.9
parOpt options redefinedparams=ignore
parameters ccoflag=1
parameters ccoflag_25=1
parameters ccoflag_25od33=1
parameters ccoflag_25ud18=1
parameters ccoflag_cap=1
parameters ccoflag_cap_25=1
parameters ccoflag_ehvt=1
parameters ccoflag_hia=1
parameters ccoflag_hia25=1
parameters ccoflag_hvt=1
parameters ccoflag_lvt=1
parameters ccoflag_na=1
parameters ccoflag_na25=1
parameters ccoflag_uhvt=1
parameters ccoflag_ulvt=1
parameters rcoflag=1
parameters rcoflag_25=1
parameters rcoflag_25od33=1
parameters rcoflag_25ud18=1
parameters rcoflag_ehvt=1
parameters rcoflag_hia=1
parameters rcoflag_hia25=1
parameters rcoflag_hvt=1
parameters rcoflag_lvt=1
parameters rcoflag_na=1
parameters rcoflag_na25=1
parameters rcoflag_uhvt=1
parameters rcoflag_ulvt=1
parameters rgflag=1
parameters rgflag_25=1
parameters rgflag_25od33=1
parameters rgflag_25ud18=1
parameters rgflag_ehvt=1
parameters rgflag_hia=1
parameters rgflag_hia25=1
parameters rgflag_hvt=1
parameters rgflag_lvt=1
parameters rgflag_na=1
parameters rgflag_na25=1
parameters rgflag_uhvt=1
parameters rgflag_ulvt=1
endsection pre_simu

section noise_typical
setscale options scalefactor=0.9
parOpt options redefinedparams=ignore
parameters noiseflagn=0
parameters noiseflagp=0
parameters noiseflagn_25=0
parameters noiseflagp_25=0
parameters noiseflagn_25od33=0
parameters noiseflagp_25od33=0
parameters noiseflagn_25ud18=0
parameters noiseflagp_25ud18=0
parameters noiseflagn_hvt=0
parameters noiseflagp_hvt=0
parameters noiseflagn_lvt=0
parameters noiseflagp_lvt=0
parameters rnoiseflag_res=0
parameters rnoiseflag_disres=0
endsection noise_typical

section noise_worst
setscale options scalefactor=0.9
parOpt options redefinedparams=ignore
parameters noiseflagn=1
parameters noiseflagp=1
parameters noiseflagn_25=1
parameters noiseflagp_25=1
parameters noiseflagn_25od33=1
parameters noiseflagp_25od33=1
parameters noiseflagn_25ud18=1
parameters noiseflagp_25ud18=1
parameters noiseflagn_hvt=1
parameters noiseflagp_hvt=1
parameters noiseflagn_lvt=1
parameters noiseflagp_lvt=1
parameters rnoiseflag_res=1
parameters rnoiseflag_disres=1
endsection noise_worst

section noise_best
setscale options scalefactor=0.9
parOpt options redefinedparams=ignore
parameters noiseflagn=-1
parameters noiseflagp=-1
parameters noiseflagn_25=-1
parameters noiseflagp_25=-1
parameters noiseflagn_25od33=-1
parameters noiseflagp_25od33=-1
parameters noiseflagn_25ud18=-1
parameters noiseflagp_25ud18=-1
parameters noiseflagn_hvt=-1
parameters noiseflagp_hvt=-1
parameters noiseflagn_lvt=-1
parameters noiseflagp_lvt=-1
parameters rnoiseflag_res=-1
parameters rnoiseflag_disres=-1
endsection noise_best

section noise_mc
include "crn28hpcp_lct_2d5_elk_v1d0_2p1_shrink0d9_embedded_usage.scs" section=noise_typical
parOpt options redefinedparams=ignore
parameters noiseflagn_mc=1
parameters noiseflagp_mc=1
parameters noiseflagn_25_mc=1
parameters noiseflagp_25_mc=1
parameters noiseflagn_25od33_mc=1
parameters noiseflagp_25od33_mc=1
parameters noiseflagn_25ud18_mc=1
parameters noiseflagp_25ud18_mc=1
parameters noiseflagn_hvt_mc=1
parameters noiseflagp_hvt_mc=1
parameters noiseflagn_lvt_mc=1
parameters noiseflagp_lvt_mc=1
endsection noise_mc

section ttmacro_mos_moscap
setscale options scalefactor=0.9
include "crn28hpcp_lct_2d5_elk_v1d0_2p1.scs" section=tt
include "crn28hpcp_lct_2d5_elk_v1d0_2p1.scs" section=tt_25
include "crn28hpcp_lct_2d5_elk_v1d0_2p1.scs" section=tt_25od33
include "crn28hpcp_lct_2d5_elk_v1d0_2p1.scs" section=tt_25ud18
include "crn28hpcp_lct_2d5_elk_v1d0_2p1.scs" section=tt_ehvt
include "crn28hpcp_lct_2d5_elk_v1d0_2p1.scs" section=tt_hia
include "crn28hpcp_lct_2d5_elk_v1d0_2p1.scs" section=tt_hia25
include "crn28hpcp_lct_2d5_elk_v1d0_2p1.scs" section=tt_hvt
include "crn28hpcp_lct_2d5_elk_v1d0_2p1.scs" section=tt_lvt
include "crn28hpcp_lct_2d5_elk_v1d0_2p1.scs" section=tt_rfmvar
include "crn28hpcp_lct_2d5_elk_v1d0_2p1.scs" section=tt_rfmvar_25
include "crn28hpcp_lct_2d5_elk_v1d0_2p1.scs" section=tt_mos_cap
include "crn28hpcp_lct_2d5_elk_v1d0_2p1.scs" section=tt_mos_cap_25
include "crn28hpcp_lct_2d5_elk_v1d0_2p1.scs" section=tt_na
include "crn28hpcp_lct_2d5_elk_v1d0_2p1.scs" section=tt_na25
include "crn28hpcp_lct_2d5_elk_v1d0_2p1.scs" section=tt_uhvt
include "crn28hpcp_lct_2d5_elk_v1d0_2p1.scs" section=tt_ulvt
include "crn28hpcp_lct_2d5_elk_v1d0_2p1.scs" section=global
include "crn28hpcp_lct_2d5_elk_v1d0_2p1.scs" section=global_25
include "crn28hpcp_lct_2d5_elk_v1d0_2p1.scs" section=global_25od33
include "crn28hpcp_lct_2d5_elk_v1d0_2p1.scs" section=global_25ud18
include "crn28hpcp_lct_2d5_elk_v1d0_2p1.scs" section=global_ehvt
include "crn28hpcp_lct_2d5_elk_v1d0_2p1.scs" section=global_hvt
include "crn28hpcp_lct_2d5_elk_v1d0_2p1.scs" section=global_lvt
include "crn28hpcp_lct_2d5_elk_v1d0_2p1.scs" section=global_na
include "crn28hpcp_lct_2d5_elk_v1d0_2p1.scs" section=global_na25
include "crn28hpcp_lct_2d5_elk_v1d0_2p1.scs" section=global_uhvt
include "crn28hpcp_lct_2d5_elk_v1d0_2p1.scs" section=global_ulvt
include "crn28hpcp_lct_2d5_elk_v1d0_2p1.scs" section=total
include "crn28hpcp_lct_2d5_elk_v1d0_2p1.scs" section=total_25
include "crn28hpcp_lct_2d5_elk_v1d0_2p1.scs" section=total_25od33
include "crn28hpcp_lct_2d5_elk_v1d0_2p1.scs" section=total_25ud18
include "crn28hpcp_lct_2d5_elk_v1d0_2p1.scs" section=total_ehvt
include "crn28hpcp_lct_2d5_elk_v1d0_2p1.scs" section=total_hvt
include "crn28hpcp_lct_2d5_elk_v1d0_2p1.scs" section=total_lvt
include "crn28hpcp_lct_2d5_elk_v1d0_2p1.scs" section=total_na
include "crn28hpcp_lct_2d5_elk_v1d0_2p1.scs" section=total_na25
include "crn28hpcp_lct_2d5_elk_v1d0_2p1.scs" section=total_uhvt
include "crn28hpcp_lct_2d5_elk_v1d0_2p1.scs" section=total_ulvt
include "crn28hpcp_lct_2d5_elk_v1d0_2p1.scs" section=stat
endsection ttmacro_mos_moscap

section ssmacro_mos_moscap
setscale options scalefactor=0.9
include "crn28hpcp_lct_2d5_elk_v1d0_2p1.scs" section=ss
include "crn28hpcp_lct_2d5_elk_v1d0_2p1.scs" section=ss_25
include "crn28hpcp_lct_2d5_elk_v1d0_2p1.scs" section=ss_25od33
include "crn28hpcp_lct_2d5_elk_v1d0_2p1.scs" section=ss_25ud18
include "crn28hpcp_lct_2d5_elk_v1d0_2p1.scs" section=ss_ehvt
include "crn28hpcp_lct_2d5_elk_v1d0_2p1.scs" section=ss_hia
include "crn28hpcp_lct_2d5_elk_v1d0_2p1.scs" section=ss_hia25
include "crn28hpcp_lct_2d5_elk_v1d0_2p1.scs" section=ss_hvt
include "crn28hpcp_lct_2d5_elk_v1d0_2p1.scs" section=ss_lvt
include "crn28hpcp_lct_2d5_elk_v1d0_2p1.scs" section=ss_rfmvar
include "crn28hpcp_lct_2d5_elk_v1d0_2p1.scs" section=ss_rfmvar_25
include "crn28hpcp_lct_2d5_elk_v1d0_2p1.scs" section=ss_mos_cap
include "crn28hpcp_lct_2d5_elk_v1d0_2p1.scs" section=ss_mos_cap_25
include "crn28hpcp_lct_2d5_elk_v1d0_2p1.scs" section=ss_na
include "crn28hpcp_lct_2d5_elk_v1d0_2p1.scs" section=ss_na25
include "crn28hpcp_lct_2d5_elk_v1d0_2p1.scs" section=ss_uhvt
include "crn28hpcp_lct_2d5_elk_v1d0_2p1.scs" section=ss_ulvt
include "crn28hpcp_lct_2d5_elk_v1d0_2p1.scs" section=global
include "crn28hpcp_lct_2d5_elk_v1d0_2p1.scs" section=global_25
include "crn28hpcp_lct_2d5_elk_v1d0_2p1.scs" section=global_25od33
include "crn28hpcp_lct_2d5_elk_v1d0_2p1.scs" section=global_25ud18
include "crn28hpcp_lct_2d5_elk_v1d0_2p1.scs" section=global_ehvt
include "crn28hpcp_lct_2d5_elk_v1d0_2p1.scs" section=global_hvt
include "crn28hpcp_lct_2d5_elk_v1d0_2p1.scs" section=global_lvt
include "crn28hpcp_lct_2d5_elk_v1d0_2p1.scs" section=global_na
include "crn28hpcp_lct_2d5_elk_v1d0_2p1.scs" section=global_na25
include "crn28hpcp_lct_2d5_elk_v1d0_2p1.scs" section=global_uhvt
include "crn28hpcp_lct_2d5_elk_v1d0_2p1.scs" section=global_ulvt
include "crn28hpcp_lct_2d5_elk_v1d0_2p1.scs" section=total
include "crn28hpcp_lct_2d5_elk_v1d0_2p1.scs" section=total_25
include "crn28hpcp_lct_2d5_elk_v1d0_2p1.scs" section=total_25od33
include "crn28hpcp_lct_2d5_elk_v1d0_2p1.scs" section=total_25ud18
include "crn28hpcp_lct_2d5_elk_v1d0_2p1.scs" section=total_ehvt
include "crn28hpcp_lct_2d5_elk_v1d0_2p1.scs" section=total_hvt
include "crn28hpcp_lct_2d5_elk_v1d0_2p1.scs" section=total_lvt
include "crn28hpcp_lct_2d5_elk_v1d0_2p1.scs" section=total_na
include "crn28hpcp_lct_2d5_elk_v1d0_2p1.scs" section=total_na25
include "crn28hpcp_lct_2d5_elk_v1d0_2p1.scs" section=total_uhvt
include "crn28hpcp_lct_2d5_elk_v1d0_2p1.scs" section=total_ulvt
include "crn28hpcp_lct_2d5_elk_v1d0_2p1.scs" section=stat
endsection ssmacro_mos_moscap

section ffmacro_mos_moscap
setscale options scalefactor=0.9
include "crn28hpcp_lct_2d5_elk_v1d0_2p1.scs" section=ff
include "crn28hpcp_lct_2d5_elk_v1d0_2p1.scs" section=ff_25
include "crn28hpcp_lct_2d5_elk_v1d0_2p1.scs" section=ff_25od33
include "crn28hpcp_lct_2d5_elk_v1d0_2p1.scs" section=ff_25ud18
include "crn28hpcp_lct_2d5_elk_v1d0_2p1.scs" section=ff_ehvt
include "crn28hpcp_lct_2d5_elk_v1d0_2p1.scs" section=ff_hia
include "crn28hpcp_lct_2d5_elk_v1d0_2p1.scs" section=ff_hia25
include "crn28hpcp_lct_2d5_elk_v1d0_2p1.scs" section=ff_hvt
include "crn28hpcp_lct_2d5_elk_v1d0_2p1.scs" section=ff_lvt
include "crn28hpcp_lct_2d5_elk_v1d0_2p1.scs" section=ff_rfmvar
include "crn28hpcp_lct_2d5_elk_v1d0_2p1.scs" section=ff_rfmvar_25
include "crn28hpcp_lct_2d5_elk_v1d0_2p1.scs" section=ff_mos_cap
include "crn28hpcp_lct_2d5_elk_v1d0_2p1.scs" section=ff_mos_cap_25
include "crn28hpcp_lct_2d5_elk_v1d0_2p1.scs" section=ff_na
include "crn28hpcp_lct_2d5_elk_v1d0_2p1.scs" section=ff_na25
include "crn28hpcp_lct_2d5_elk_v1d0_2p1.scs" section=ff_uhvt
include "crn28hpcp_lct_2d5_elk_v1d0_2p1.scs" section=ff_ulvt
include "crn28hpcp_lct_2d5_elk_v1d0_2p1.scs" section=global
include "crn28hpcp_lct_2d5_elk_v1d0_2p1.scs" section=global_25
include "crn28hpcp_lct_2d5_elk_v1d0_2p1.scs" section=global_25od33
include "crn28hpcp_lct_2d5_elk_v1d0_2p1.scs" section=global_25ud18
include "crn28hpcp_lct_2d5_elk_v1d0_2p1.scs" section=global_ehvt
include "crn28hpcp_lct_2d5_elk_v1d0_2p1.scs" section=global_hvt
include "crn28hpcp_lct_2d5_elk_v1d0_2p1.scs" section=global_lvt
include "crn28hpcp_lct_2d5_elk_v1d0_2p1.scs" section=global_na
include "crn28hpcp_lct_2d5_elk_v1d0_2p1.scs" section=global_na25
include "crn28hpcp_lct_2d5_elk_v1d0_2p1.scs" section=global_uhvt
include "crn28hpcp_lct_2d5_elk_v1d0_2p1.scs" section=global_ulvt
include "crn28hpcp_lct_2d5_elk_v1d0_2p1.scs" section=total
include "crn28hpcp_lct_2d5_elk_v1d0_2p1.scs" section=total_25
include "crn28hpcp_lct_2d5_elk_v1d0_2p1.scs" section=total_25od33
include "crn28hpcp_lct_2d5_elk_v1d0_2p1.scs" section=total_25ud18
include "crn28hpcp_lct_2d5_elk_v1d0_2p1.scs" section=total_ehvt
include "crn28hpcp_lct_2d5_elk_v1d0_2p1.scs" section=total_hvt
include "crn28hpcp_lct_2d5_elk_v1d0_2p1.scs" section=total_lvt
include "crn28hpcp_lct_2d5_elk_v1d0_2p1.scs" section=total_na
include "crn28hpcp_lct_2d5_elk_v1d0_2p1.scs" section=total_na25
include "crn28hpcp_lct_2d5_elk_v1d0_2p1.scs" section=total_uhvt
include "crn28hpcp_lct_2d5_elk_v1d0_2p1.scs" section=total_ulvt
include "crn28hpcp_lct_2d5_elk_v1d0_2p1.scs" section=stat
endsection ffmacro_mos_moscap

section sfmacro_mos_moscap
setscale options scalefactor=0.9
include "crn28hpcp_lct_2d5_elk_v1d0_2p1.scs" section=sf
include "crn28hpcp_lct_2d5_elk_v1d0_2p1.scs" section=sf_25
include "crn28hpcp_lct_2d5_elk_v1d0_2p1.scs" section=sf_25od33
include "crn28hpcp_lct_2d5_elk_v1d0_2p1.scs" section=sf_25ud18
include "crn28hpcp_lct_2d5_elk_v1d0_2p1.scs" section=sf_ehvt
include "crn28hpcp_lct_2d5_elk_v1d0_2p1.scs" section=sf_hia
include "crn28hpcp_lct_2d5_elk_v1d0_2p1.scs" section=sf_hia25
include "crn28hpcp_lct_2d5_elk_v1d0_2p1.scs" section=sf_hvt
include "crn28hpcp_lct_2d5_elk_v1d0_2p1.scs" section=sf_lvt
include "crn28hpcp_lct_2d5_elk_v1d0_2p1.scs" section=sf_na
include "crn28hpcp_lct_2d5_elk_v1d0_2p1.scs" section=sf_na25
include "crn28hpcp_lct_2d5_elk_v1d0_2p1.scs" section=sf_uhvt
include "crn28hpcp_lct_2d5_elk_v1d0_2p1.scs" section=sf_ulvt
include "crn28hpcp_lct_2d5_elk_v1d0_2p1.scs" section=tt_rfmvar
include "crn28hpcp_lct_2d5_elk_v1d0_2p1.scs" section=tt_rfmvar_25
include "crn28hpcp_lct_2d5_elk_v1d0_2p1.scs" section=tt_mos_cap
include "crn28hpcp_lct_2d5_elk_v1d0_2p1.scs" section=tt_mos_cap_25
include "crn28hpcp_lct_2d5_elk_v1d0_2p1.scs" section=global
include "crn28hpcp_lct_2d5_elk_v1d0_2p1.scs" section=global_25
include "crn28hpcp_lct_2d5_elk_v1d0_2p1.scs" section=global_25od33
include "crn28hpcp_lct_2d5_elk_v1d0_2p1.scs" section=global_25ud18
include "crn28hpcp_lct_2d5_elk_v1d0_2p1.scs" section=global_ehvt
include "crn28hpcp_lct_2d5_elk_v1d0_2p1.scs" section=global_hvt
include "crn28hpcp_lct_2d5_elk_v1d0_2p1.scs" section=global_lvt
include "crn28hpcp_lct_2d5_elk_v1d0_2p1.scs" section=global_na
include "crn28hpcp_lct_2d5_elk_v1d0_2p1.scs" section=global_na25
include "crn28hpcp_lct_2d5_elk_v1d0_2p1.scs" section=global_uhvt
include "crn28hpcp_lct_2d5_elk_v1d0_2p1.scs" section=global_ulvt
include "crn28hpcp_lct_2d5_elk_v1d0_2p1.scs" section=total
include "crn28hpcp_lct_2d5_elk_v1d0_2p1.scs" section=total_25
include "crn28hpcp_lct_2d5_elk_v1d0_2p1.scs" section=total_25od33
include "crn28hpcp_lct_2d5_elk_v1d0_2p1.scs" section=total_25ud18
include "crn28hpcp_lct_2d5_elk_v1d0_2p1.scs" section=total_ehvt
include "crn28hpcp_lct_2d5_elk_v1d0_2p1.scs" section=total_hvt
include "crn28hpcp_lct_2d5_elk_v1d0_2p1.scs" section=total_lvt
include "crn28hpcp_lct_2d5_elk_v1d0_2p1.scs" section=total_na
include "crn28hpcp_lct_2d5_elk_v1d0_2p1.scs" section=total_na25
include "crn28hpcp_lct_2d5_elk_v1d0_2p1.scs" section=total_uhvt
include "crn28hpcp_lct_2d5_elk_v1d0_2p1.scs" section=total_ulvt
include "crn28hpcp_lct_2d5_elk_v1d0_2p1.scs" section=stat
endsection sfmacro_mos_moscap

section fsmacro_mos_moscap
setscale options scalefactor=0.9
include "crn28hpcp_lct_2d5_elk_v1d0_2p1.scs" section=fs
include "crn28hpcp_lct_2d5_elk_v1d0_2p1.scs" section=fs_25
include "crn28hpcp_lct_2d5_elk_v1d0_2p1.scs" section=fs_25od33
include "crn28hpcp_lct_2d5_elk_v1d0_2p1.scs" section=fs_25ud18
include "crn28hpcp_lct_2d5_elk_v1d0_2p1.scs" section=fs_ehvt
include "crn28hpcp_lct_2d5_elk_v1d0_2p1.scs" section=fs_hia
include "crn28hpcp_lct_2d5_elk_v1d0_2p1.scs" section=fs_hia25
include "crn28hpcp_lct_2d5_elk_v1d0_2p1.scs" section=fs_hvt
include "crn28hpcp_lct_2d5_elk_v1d0_2p1.scs" section=fs_lvt
include "crn28hpcp_lct_2d5_elk_v1d0_2p1.scs" section=fs_na
include "crn28hpcp_lct_2d5_elk_v1d0_2p1.scs" section=fs_na25
include "crn28hpcp_lct_2d5_elk_v1d0_2p1.scs" section=fs_uhvt
include "crn28hpcp_lct_2d5_elk_v1d0_2p1.scs" section=fs_ulvt
include "crn28hpcp_lct_2d5_elk_v1d0_2p1.scs" section=tt_rfmvar
include "crn28hpcp_lct_2d5_elk_v1d0_2p1.scs" section=tt_rfmvar_25
include "crn28hpcp_lct_2d5_elk_v1d0_2p1.scs" section=tt_mos_cap
include "crn28hpcp_lct_2d5_elk_v1d0_2p1.scs" section=tt_mos_cap_25
include "crn28hpcp_lct_2d5_elk_v1d0_2p1.scs" section=global
include "crn28hpcp_lct_2d5_elk_v1d0_2p1.scs" section=global_25
include "crn28hpcp_lct_2d5_elk_v1d0_2p1.scs" section=global_25od33
include "crn28hpcp_lct_2d5_elk_v1d0_2p1.scs" section=global_25ud18
include "crn28hpcp_lct_2d5_elk_v1d0_2p1.scs" section=global_ehvt
include "crn28hpcp_lct_2d5_elk_v1d0_2p1.scs" section=global_hvt
include "crn28hpcp_lct_2d5_elk_v1d0_2p1.scs" section=global_lvt
include "crn28hpcp_lct_2d5_elk_v1d0_2p1.scs" section=global_na
include "crn28hpcp_lct_2d5_elk_v1d0_2p1.scs" section=global_na25
include "crn28hpcp_lct_2d5_elk_v1d0_2p1.scs" section=global_uhvt
include "crn28hpcp_lct_2d5_elk_v1d0_2p1.scs" section=global_ulvt
include "crn28hpcp_lct_2d5_elk_v1d0_2p1.scs" section=total
include "crn28hpcp_lct_2d5_elk_v1d0_2p1.scs" section=total_25
include "crn28hpcp_lct_2d5_elk_v1d0_2p1.scs" section=total_25od33
include "crn28hpcp_lct_2d5_elk_v1d0_2p1.scs" section=total_25ud18
include "crn28hpcp_lct_2d5_elk_v1d0_2p1.scs" section=total_ehvt
include "crn28hpcp_lct_2d5_elk_v1d0_2p1.scs" section=total_hvt
include "crn28hpcp_lct_2d5_elk_v1d0_2p1.scs" section=total_lvt
include "crn28hpcp_lct_2d5_elk_v1d0_2p1.scs" section=total_na
include "crn28hpcp_lct_2d5_elk_v1d0_2p1.scs" section=total_na25
include "crn28hpcp_lct_2d5_elk_v1d0_2p1.scs" section=total_uhvt
include "crn28hpcp_lct_2d5_elk_v1d0_2p1.scs" section=total_ulvt
include "crn28hpcp_lct_2d5_elk_v1d0_2p1.scs" section=stat
endsection fsmacro_mos_moscap

section ttglobalcorner_localmc_mos_moscap
setscale options scalefactor=0.9
include "crn28hpcp_lct_2d5_elk_v1d0_2p1.scs" section=tt
include "crn28hpcp_lct_2d5_elk_v1d0_2p1.scs" section=tt_25
include "crn28hpcp_lct_2d5_elk_v1d0_2p1.scs" section=tt_25od33
include "crn28hpcp_lct_2d5_elk_v1d0_2p1.scs" section=tt_25ud18
include "crn28hpcp_lct_2d5_elk_v1d0_2p1.scs" section=tt_ehvt
include "crn28hpcp_lct_2d5_elk_v1d0_2p1.scs" section=tt_hia
include "crn28hpcp_lct_2d5_elk_v1d0_2p1.scs" section=tt_hia25
include "crn28hpcp_lct_2d5_elk_v1d0_2p1.scs" section=tt_hvt
include "crn28hpcp_lct_2d5_elk_v1d0_2p1.scs" section=tt_lvt
include "crn28hpcp_lct_2d5_elk_v1d0_2p1.scs" section=tt_rfmvar
include "crn28hpcp_lct_2d5_elk_v1d0_2p1.scs" section=tt_rfmvar_25
include "crn28hpcp_lct_2d5_elk_v1d0_2p1.scs" section=tt_mos_cap
include "crn28hpcp_lct_2d5_elk_v1d0_2p1.scs" section=tt_mos_cap_25
include "crn28hpcp_lct_2d5_elk_v1d0_2p1.scs" section=tt_na
include "crn28hpcp_lct_2d5_elk_v1d0_2p1.scs" section=tt_na25
include "crn28hpcp_lct_2d5_elk_v1d0_2p1.scs" section=tt_uhvt
include "crn28hpcp_lct_2d5_elk_v1d0_2p1.scs" section=tt_ulvt
include "crn28hpcp_lct_2d5_elk_v1d0_2p1.scs" section=ttg
include "crn28hpcp_lct_2d5_elk_v1d0_2p1.scs" section=ttg_25
include "crn28hpcp_lct_2d5_elk_v1d0_2p1.scs" section=ttg_25od33
include "crn28hpcp_lct_2d5_elk_v1d0_2p1.scs" section=ttg_25ud18
include "crn28hpcp_lct_2d5_elk_v1d0_2p1.scs" section=ttg_ehvt
include "crn28hpcp_lct_2d5_elk_v1d0_2p1.scs" section=ttg_hvt
include "crn28hpcp_lct_2d5_elk_v1d0_2p1.scs" section=ttg_lvt
include "crn28hpcp_lct_2d5_elk_v1d0_2p1.scs" section=ttg_na
include "crn28hpcp_lct_2d5_elk_v1d0_2p1.scs" section=ttg_na25
include "crn28hpcp_lct_2d5_elk_v1d0_2p1.scs" section=ttg_uhvt
include "crn28hpcp_lct_2d5_elk_v1d0_2p1.scs" section=ttg_ulvt
include "crn28hpcp_lct_2d5_elk_v1d0_2p1.scs" section=total
include "crn28hpcp_lct_2d5_elk_v1d0_2p1.scs" section=total_25
include "crn28hpcp_lct_2d5_elk_v1d0_2p1.scs" section=total_25od33
include "crn28hpcp_lct_2d5_elk_v1d0_2p1.scs" section=total_25ud18
include "crn28hpcp_lct_2d5_elk_v1d0_2p1.scs" section=total_ehvt
include "crn28hpcp_lct_2d5_elk_v1d0_2p1.scs" section=total_hvt
include "crn28hpcp_lct_2d5_elk_v1d0_2p1.scs" section=total_lvt
include "crn28hpcp_lct_2d5_elk_v1d0_2p1.scs" section=total_na
include "crn28hpcp_lct_2d5_elk_v1d0_2p1.scs" section=total_na25
include "crn28hpcp_lct_2d5_elk_v1d0_2p1.scs" section=total_uhvt
include "crn28hpcp_lct_2d5_elk_v1d0_2p1.scs" section=total_ulvt
include "crn28hpcp_lct_2d5_elk_v1d0_2p1.scs" section=stat
parOpt options redefinedparams=ignore
parameters totalflag_mos=0
parameters totalflag_mos_25=0
parameters totalflag_mos_25od33=0
parameters totalflag_mos_25ud18=0
parameters totalflag_mos_ehvt=0
parameters totalflag_mos_hvt=0
parameters totalflag_mos_lvt=0
parameters totalflag_mos_na25=0
parameters totalflag_mos_na=0
parameters totalflag_mos_uhvt=0
parameters totalflag_mos_ulvt=0
endsection ttglobalcorner_localmc_mos_moscap

section ssglobalcorner_localmc_mos_moscap
setscale options scalefactor=0.9
include "crn28hpcp_lct_2d5_elk_v1d0_2p1.scs" section=ss_hia
include "crn28hpcp_lct_2d5_elk_v1d0_2p1.scs" section=ss_hia25
include "crn28hpcp_lct_2d5_elk_v1d0_2p1.scs" section=ss_rfmvar
include "crn28hpcp_lct_2d5_elk_v1d0_2p1.scs" section=ss_rfmvar_25
include "crn28hpcp_lct_2d5_elk_v1d0_2p1.scs" section=ss_mos_cap
include "crn28hpcp_lct_2d5_elk_v1d0_2p1.scs" section=ss_mos_cap_25
include "crn28hpcp_lct_2d5_elk_v1d0_2p1.scs" section=ssg
include "crn28hpcp_lct_2d5_elk_v1d0_2p1.scs" section=ssg_25
include "crn28hpcp_lct_2d5_elk_v1d0_2p1.scs" section=ssg_25od33
include "crn28hpcp_lct_2d5_elk_v1d0_2p1.scs" section=ssg_25ud18
include "crn28hpcp_lct_2d5_elk_v1d0_2p1.scs" section=ssg_ehvt
include "crn28hpcp_lct_2d5_elk_v1d0_2p1.scs" section=ssg_hvt
include "crn28hpcp_lct_2d5_elk_v1d0_2p1.scs" section=ssg_lvt
include "crn28hpcp_lct_2d5_elk_v1d0_2p1.scs" section=ssg_na
include "crn28hpcp_lct_2d5_elk_v1d0_2p1.scs" section=ssg_na25
include "crn28hpcp_lct_2d5_elk_v1d0_2p1.scs" section=ssg_uhvt
include "crn28hpcp_lct_2d5_elk_v1d0_2p1.scs" section=ssg_ulvt
include "crn28hpcp_lct_2d5_elk_v1d0_2p1.scs" section=tt
include "crn28hpcp_lct_2d5_elk_v1d0_2p1.scs" section=tt_25
include "crn28hpcp_lct_2d5_elk_v1d0_2p1.scs" section=tt_25od33
include "crn28hpcp_lct_2d5_elk_v1d0_2p1.scs" section=tt_25ud18
include "crn28hpcp_lct_2d5_elk_v1d0_2p1.scs" section=tt_ehvt
include "crn28hpcp_lct_2d5_elk_v1d0_2p1.scs" section=tt_hvt
include "crn28hpcp_lct_2d5_elk_v1d0_2p1.scs" section=tt_lvt
include "crn28hpcp_lct_2d5_elk_v1d0_2p1.scs" section=tt_na
include "crn28hpcp_lct_2d5_elk_v1d0_2p1.scs" section=tt_na25
include "crn28hpcp_lct_2d5_elk_v1d0_2p1.scs" section=tt_uhvt
include "crn28hpcp_lct_2d5_elk_v1d0_2p1.scs" section=tt_ulvt
include "crn28hpcp_lct_2d5_elk_v1d0_2p1.scs" section=total
include "crn28hpcp_lct_2d5_elk_v1d0_2p1.scs" section=total_25
include "crn28hpcp_lct_2d5_elk_v1d0_2p1.scs" section=total_25od33
include "crn28hpcp_lct_2d5_elk_v1d0_2p1.scs" section=total_25ud18
include "crn28hpcp_lct_2d5_elk_v1d0_2p1.scs" section=total_ehvt
include "crn28hpcp_lct_2d5_elk_v1d0_2p1.scs" section=total_hvt
include "crn28hpcp_lct_2d5_elk_v1d0_2p1.scs" section=total_lvt
include "crn28hpcp_lct_2d5_elk_v1d0_2p1.scs" section=total_na
include "crn28hpcp_lct_2d5_elk_v1d0_2p1.scs" section=total_na25
include "crn28hpcp_lct_2d5_elk_v1d0_2p1.scs" section=total_uhvt
include "crn28hpcp_lct_2d5_elk_v1d0_2p1.scs" section=total_ulvt
include "crn28hpcp_lct_2d5_elk_v1d0_2p1.scs" section=stat
parOpt options redefinedparams=ignore
parameters totalflag_mos=0
parameters totalflag_mos_25=0
parameters totalflag_mos_25od33=0
parameters totalflag_mos_25ud18=0
parameters totalflag_mos_ehvt=0
parameters totalflag_mos_hvt=0
parameters totalflag_mos_lvt=0
parameters totalflag_mos_na25=0
parameters totalflag_mos_na=0
parameters totalflag_mos_uhvt=0
parameters totalflag_mos_ulvt=0
endsection ssglobalcorner_localmc_mos_moscap

section ffglobalcorner_localmc_mos_moscap
setscale options scalefactor=0.9
include "crn28hpcp_lct_2d5_elk_v1d0_2p1.scs" section=ff_hia
include "crn28hpcp_lct_2d5_elk_v1d0_2p1.scs" section=ff_hia25
include "crn28hpcp_lct_2d5_elk_v1d0_2p1.scs" section=ff_rfmvar
include "crn28hpcp_lct_2d5_elk_v1d0_2p1.scs" section=ff_rfmvar_25
include "crn28hpcp_lct_2d5_elk_v1d0_2p1.scs" section=ff_mos_cap
include "crn28hpcp_lct_2d5_elk_v1d0_2p1.scs" section=ff_mos_cap_25
include "crn28hpcp_lct_2d5_elk_v1d0_2p1.scs" section=ffg
include "crn28hpcp_lct_2d5_elk_v1d0_2p1.scs" section=ffg_25
include "crn28hpcp_lct_2d5_elk_v1d0_2p1.scs" section=ffg_25od33
include "crn28hpcp_lct_2d5_elk_v1d0_2p1.scs" section=ffg_25ud18
include "crn28hpcp_lct_2d5_elk_v1d0_2p1.scs" section=ffg_ehvt
include "crn28hpcp_lct_2d5_elk_v1d0_2p1.scs" section=ffg_hvt
include "crn28hpcp_lct_2d5_elk_v1d0_2p1.scs" section=ffg_lvt
include "crn28hpcp_lct_2d5_elk_v1d0_2p1.scs" section=ffg_na
include "crn28hpcp_lct_2d5_elk_v1d0_2p1.scs" section=ffg_na25
include "crn28hpcp_lct_2d5_elk_v1d0_2p1.scs" section=ffg_uhvt
include "crn28hpcp_lct_2d5_elk_v1d0_2p1.scs" section=ffg_ulvt
include "crn28hpcp_lct_2d5_elk_v1d0_2p1.scs" section=tt
include "crn28hpcp_lct_2d5_elk_v1d0_2p1.scs" section=tt_25
include "crn28hpcp_lct_2d5_elk_v1d0_2p1.scs" section=tt_25od33
include "crn28hpcp_lct_2d5_elk_v1d0_2p1.scs" section=tt_25ud18
include "crn28hpcp_lct_2d5_elk_v1d0_2p1.scs" section=tt_ehvt
include "crn28hpcp_lct_2d5_elk_v1d0_2p1.scs" section=tt_hvt
include "crn28hpcp_lct_2d5_elk_v1d0_2p1.scs" section=tt_lvt
include "crn28hpcp_lct_2d5_elk_v1d0_2p1.scs" section=tt_na
include "crn28hpcp_lct_2d5_elk_v1d0_2p1.scs" section=tt_na25
include "crn28hpcp_lct_2d5_elk_v1d0_2p1.scs" section=tt_uhvt
include "crn28hpcp_lct_2d5_elk_v1d0_2p1.scs" section=tt_ulvt
include "crn28hpcp_lct_2d5_elk_v1d0_2p1.scs" section=total
include "crn28hpcp_lct_2d5_elk_v1d0_2p1.scs" section=total_25
include "crn28hpcp_lct_2d5_elk_v1d0_2p1.scs" section=total_25od33
include "crn28hpcp_lct_2d5_elk_v1d0_2p1.scs" section=total_25ud18
include "crn28hpcp_lct_2d5_elk_v1d0_2p1.scs" section=total_ehvt
include "crn28hpcp_lct_2d5_elk_v1d0_2p1.scs" section=total_hvt
include "crn28hpcp_lct_2d5_elk_v1d0_2p1.scs" section=total_lvt
include "crn28hpcp_lct_2d5_elk_v1d0_2p1.scs" section=total_na
include "crn28hpcp_lct_2d5_elk_v1d0_2p1.scs" section=total_na25
include "crn28hpcp_lct_2d5_elk_v1d0_2p1.scs" section=total_uhvt
include "crn28hpcp_lct_2d5_elk_v1d0_2p1.scs" section=total_ulvt
include "crn28hpcp_lct_2d5_elk_v1d0_2p1.scs" section=stat
parOpt options redefinedparams=ignore
parameters totalflag_mos=0
parameters totalflag_mos_25=0
parameters totalflag_mos_25od33=0
parameters totalflag_mos_25ud18=0
parameters totalflag_mos_ehvt=0
parameters totalflag_mos_hvt=0
parameters totalflag_mos_lvt=0
parameters totalflag_mos_na25=0
parameters totalflag_mos_na=0
parameters totalflag_mos_uhvt=0
parameters totalflag_mos_ulvt=0
endsection ffglobalcorner_localmc_mos_moscap

section sfglobalcorner_localmc_mos_moscap
setscale options scalefactor=0.9
include "crn28hpcp_lct_2d5_elk_v1d0_2p1.scs" section=sf_hia
include "crn28hpcp_lct_2d5_elk_v1d0_2p1.scs" section=sf_hia25
include "crn28hpcp_lct_2d5_elk_v1d0_2p1.scs" section=sfg
include "crn28hpcp_lct_2d5_elk_v1d0_2p1.scs" section=sfg_25
include "crn28hpcp_lct_2d5_elk_v1d0_2p1.scs" section=sfg_25od33
include "crn28hpcp_lct_2d5_elk_v1d0_2p1.scs" section=sfg_25ud18
include "crn28hpcp_lct_2d5_elk_v1d0_2p1.scs" section=sfg_ehvt
include "crn28hpcp_lct_2d5_elk_v1d0_2p1.scs" section=sfg_hvt
include "crn28hpcp_lct_2d5_elk_v1d0_2p1.scs" section=sfg_lvt
include "crn28hpcp_lct_2d5_elk_v1d0_2p1.scs" section=sfg_na
include "crn28hpcp_lct_2d5_elk_v1d0_2p1.scs" section=sfg_na25
include "crn28hpcp_lct_2d5_elk_v1d0_2p1.scs" section=sfg_uhvt
include "crn28hpcp_lct_2d5_elk_v1d0_2p1.scs" section=sfg_ulvt
include "crn28hpcp_lct_2d5_elk_v1d0_2p1.scs" section=tt
include "crn28hpcp_lct_2d5_elk_v1d0_2p1.scs" section=tt_25
include "crn28hpcp_lct_2d5_elk_v1d0_2p1.scs" section=tt_25od33
include "crn28hpcp_lct_2d5_elk_v1d0_2p1.scs" section=tt_25ud18
include "crn28hpcp_lct_2d5_elk_v1d0_2p1.scs" section=tt_ehvt
include "crn28hpcp_lct_2d5_elk_v1d0_2p1.scs" section=tt_hvt
include "crn28hpcp_lct_2d5_elk_v1d0_2p1.scs" section=tt_lvt
include "crn28hpcp_lct_2d5_elk_v1d0_2p1.scs" section=tt_rfmvar
include "crn28hpcp_lct_2d5_elk_v1d0_2p1.scs" section=tt_rfmvar_25
include "crn28hpcp_lct_2d5_elk_v1d0_2p1.scs" section=tt_mos_cap
include "crn28hpcp_lct_2d5_elk_v1d0_2p1.scs" section=tt_mos_cap_25
include "crn28hpcp_lct_2d5_elk_v1d0_2p1.scs" section=tt_na
include "crn28hpcp_lct_2d5_elk_v1d0_2p1.scs" section=tt_na25
include "crn28hpcp_lct_2d5_elk_v1d0_2p1.scs" section=tt_uhvt
include "crn28hpcp_lct_2d5_elk_v1d0_2p1.scs" section=tt_ulvt
include "crn28hpcp_lct_2d5_elk_v1d0_2p1.scs" section=total
include "crn28hpcp_lct_2d5_elk_v1d0_2p1.scs" section=total_25
include "crn28hpcp_lct_2d5_elk_v1d0_2p1.scs" section=total_25od33
include "crn28hpcp_lct_2d5_elk_v1d0_2p1.scs" section=total_25ud18
include "crn28hpcp_lct_2d5_elk_v1d0_2p1.scs" section=total_ehvt
include "crn28hpcp_lct_2d5_elk_v1d0_2p1.scs" section=total_hvt
include "crn28hpcp_lct_2d5_elk_v1d0_2p1.scs" section=total_lvt
include "crn28hpcp_lct_2d5_elk_v1d0_2p1.scs" section=total_na
include "crn28hpcp_lct_2d5_elk_v1d0_2p1.scs" section=total_na25
include "crn28hpcp_lct_2d5_elk_v1d0_2p1.scs" section=total_uhvt
include "crn28hpcp_lct_2d5_elk_v1d0_2p1.scs" section=total_ulvt
include "crn28hpcp_lct_2d5_elk_v1d0_2p1.scs" section=stat
parOpt options redefinedparams=ignore
parameters totalflag_mos=0
parameters totalflag_mos_25=0
parameters totalflag_mos_25od33=0
parameters totalflag_mos_25ud18=0
parameters totalflag_mos_ehvt=0
parameters totalflag_mos_hvt=0
parameters totalflag_mos_lvt=0
parameters totalflag_mos_na25=0
parameters totalflag_mos_na=0
parameters totalflag_mos_uhvt=0
parameters totalflag_mos_ulvt=0
endsection sfglobalcorner_localmc_mos_moscap

section fsglobalcorner_localmc_mos_moscap
setscale options scalefactor=0.9
include "crn28hpcp_lct_2d5_elk_v1d0_2p1.scs" section=fs_hia
include "crn28hpcp_lct_2d5_elk_v1d0_2p1.scs" section=fs_hia25
include "crn28hpcp_lct_2d5_elk_v1d0_2p1.scs" section=fsg
include "crn28hpcp_lct_2d5_elk_v1d0_2p1.scs" section=fsg_25
include "crn28hpcp_lct_2d5_elk_v1d0_2p1.scs" section=fsg_25od33
include "crn28hpcp_lct_2d5_elk_v1d0_2p1.scs" section=fsg_25ud18
include "crn28hpcp_lct_2d5_elk_v1d0_2p1.scs" section=fsg_ehvt
include "crn28hpcp_lct_2d5_elk_v1d0_2p1.scs" section=fsg_hvt
include "crn28hpcp_lct_2d5_elk_v1d0_2p1.scs" section=fsg_lvt
include "crn28hpcp_lct_2d5_elk_v1d0_2p1.scs" section=fsg_na
include "crn28hpcp_lct_2d5_elk_v1d0_2p1.scs" section=fsg_na25
include "crn28hpcp_lct_2d5_elk_v1d0_2p1.scs" section=fsg_uhvt
include "crn28hpcp_lct_2d5_elk_v1d0_2p1.scs" section=fsg_ulvt
include "crn28hpcp_lct_2d5_elk_v1d0_2p1.scs" section=tt
include "crn28hpcp_lct_2d5_elk_v1d0_2p1.scs" section=tt_25
include "crn28hpcp_lct_2d5_elk_v1d0_2p1.scs" section=tt_25od33
include "crn28hpcp_lct_2d5_elk_v1d0_2p1.scs" section=tt_25ud18
include "crn28hpcp_lct_2d5_elk_v1d0_2p1.scs" section=tt_ehvt
include "crn28hpcp_lct_2d5_elk_v1d0_2p1.scs" section=tt_hvt
include "crn28hpcp_lct_2d5_elk_v1d0_2p1.scs" section=tt_lvt
include "crn28hpcp_lct_2d5_elk_v1d0_2p1.scs" section=tt_rfmvar
include "crn28hpcp_lct_2d5_elk_v1d0_2p1.scs" section=tt_rfmvar_25
include "crn28hpcp_lct_2d5_elk_v1d0_2p1.scs" section=tt_mos_cap
include "crn28hpcp_lct_2d5_elk_v1d0_2p1.scs" section=tt_mos_cap_25
include "crn28hpcp_lct_2d5_elk_v1d0_2p1.scs" section=tt_na
include "crn28hpcp_lct_2d5_elk_v1d0_2p1.scs" section=tt_na25
include "crn28hpcp_lct_2d5_elk_v1d0_2p1.scs" section=tt_uhvt
include "crn28hpcp_lct_2d5_elk_v1d0_2p1.scs" section=tt_ulvt
include "crn28hpcp_lct_2d5_elk_v1d0_2p1.scs" section=total
include "crn28hpcp_lct_2d5_elk_v1d0_2p1.scs" section=total_25
include "crn28hpcp_lct_2d5_elk_v1d0_2p1.scs" section=total_25od33
include "crn28hpcp_lct_2d5_elk_v1d0_2p1.scs" section=total_25ud18
include "crn28hpcp_lct_2d5_elk_v1d0_2p1.scs" section=total_ehvt
include "crn28hpcp_lct_2d5_elk_v1d0_2p1.scs" section=total_hvt
include "crn28hpcp_lct_2d5_elk_v1d0_2p1.scs" section=total_lvt
include "crn28hpcp_lct_2d5_elk_v1d0_2p1.scs" section=total_na
include "crn28hpcp_lct_2d5_elk_v1d0_2p1.scs" section=total_na25
include "crn28hpcp_lct_2d5_elk_v1d0_2p1.scs" section=total_uhvt
include "crn28hpcp_lct_2d5_elk_v1d0_2p1.scs" section=total_ulvt
include "crn28hpcp_lct_2d5_elk_v1d0_2p1.scs" section=stat
parOpt options redefinedparams=ignore
parameters totalflag_mos=0
parameters totalflag_mos_25=0
parameters totalflag_mos_25od33=0
parameters totalflag_mos_25ud18=0
parameters totalflag_mos_ehvt=0
parameters totalflag_mos_hvt=0
parameters totalflag_mos_lvt=0
parameters totalflag_mos_na25=0
parameters totalflag_mos_na=0
parameters totalflag_mos_uhvt=0
parameters totalflag_mos_ulvt=0
endsection fsglobalcorner_localmc_mos_moscap

section localmconly_mos_moscap
setscale options scalefactor=0.9
include "crn28hpcp_lct_2d5_elk_v1d0_2p1.scs" section=tt
include "crn28hpcp_lct_2d5_elk_v1d0_2p1.scs" section=tt_25
include "crn28hpcp_lct_2d5_elk_v1d0_2p1.scs" section=tt_25od33
include "crn28hpcp_lct_2d5_elk_v1d0_2p1.scs" section=tt_25ud18
include "crn28hpcp_lct_2d5_elk_v1d0_2p1.scs" section=tt_ehvt
include "crn28hpcp_lct_2d5_elk_v1d0_2p1.scs" section=tt_hia
include "crn28hpcp_lct_2d5_elk_v1d0_2p1.scs" section=tt_hia25
include "crn28hpcp_lct_2d5_elk_v1d0_2p1.scs" section=tt_hvt
include "crn28hpcp_lct_2d5_elk_v1d0_2p1.scs" section=tt_lvt
include "crn28hpcp_lct_2d5_elk_v1d0_2p1.scs" section=tt_rfmvar
include "crn28hpcp_lct_2d5_elk_v1d0_2p1.scs" section=tt_rfmvar_25
include "crn28hpcp_lct_2d5_elk_v1d0_2p1.scs" section=tt_mos_cap
include "crn28hpcp_lct_2d5_elk_v1d0_2p1.scs" section=tt_mos_cap_25
include "crn28hpcp_lct_2d5_elk_v1d0_2p1.scs" section=tt_na
include "crn28hpcp_lct_2d5_elk_v1d0_2p1.scs" section=tt_na25
include "crn28hpcp_lct_2d5_elk_v1d0_2p1.scs" section=tt_uhvt
include "crn28hpcp_lct_2d5_elk_v1d0_2p1.scs" section=tt_ulvt
include "crn28hpcp_lct_2d5_elk_v1d0_2p1.scs" section=global
include "crn28hpcp_lct_2d5_elk_v1d0_2p1.scs" section=global_25
include "crn28hpcp_lct_2d5_elk_v1d0_2p1.scs" section=global_25od33
include "crn28hpcp_lct_2d5_elk_v1d0_2p1.scs" section=global_25ud18
include "crn28hpcp_lct_2d5_elk_v1d0_2p1.scs" section=global_ehvt
include "crn28hpcp_lct_2d5_elk_v1d0_2p1.scs" section=global_hvt
include "crn28hpcp_lct_2d5_elk_v1d0_2p1.scs" section=global_lvt
include "crn28hpcp_lct_2d5_elk_v1d0_2p1.scs" section=global_na
include "crn28hpcp_lct_2d5_elk_v1d0_2p1.scs" section=global_na25
include "crn28hpcp_lct_2d5_elk_v1d0_2p1.scs" section=global_uhvt
include "crn28hpcp_lct_2d5_elk_v1d0_2p1.scs" section=global_ulvt
include "crn28hpcp_lct_2d5_elk_v1d0_2p1.scs" section=total
include "crn28hpcp_lct_2d5_elk_v1d0_2p1.scs" section=total_25
include "crn28hpcp_lct_2d5_elk_v1d0_2p1.scs" section=total_25od33
include "crn28hpcp_lct_2d5_elk_v1d0_2p1.scs" section=total_25ud18
include "crn28hpcp_lct_2d5_elk_v1d0_2p1.scs" section=total_ehvt
include "crn28hpcp_lct_2d5_elk_v1d0_2p1.scs" section=total_hvt
include "crn28hpcp_lct_2d5_elk_v1d0_2p1.scs" section=total_lvt
include "crn28hpcp_lct_2d5_elk_v1d0_2p1.scs" section=total_na
include "crn28hpcp_lct_2d5_elk_v1d0_2p1.scs" section=total_na25
include "crn28hpcp_lct_2d5_elk_v1d0_2p1.scs" section=total_uhvt
include "crn28hpcp_lct_2d5_elk_v1d0_2p1.scs" section=total_ulvt
include "crn28hpcp_lct_2d5_elk_v1d0_2p1.scs" section=stat
parOpt options redefinedparams=ignore
parameters globalflag_mos=0
parameters globalflag_mos_25=0
parameters globalflag_mos_25od33=0
parameters globalflag_mos_25ud18=0
parameters globalflag_mos_ehvt=0
parameters globalflag_mos_hvt=0
parameters globalflag_mos_lvt=0
parameters globalflag_mos_na25=0
parameters globalflag_mos_na=0
parameters globalflag_mos_uhvt=0
parameters globalflag_mos_ulvt=0
parameters totalflag_mos=0
parameters totalflag_mos_25=0
parameters totalflag_mos_25od33=0
parameters totalflag_mos_25ud18=0
parameters totalflag_mos_ehvt=0
parameters totalflag_mos_hvt=0
parameters totalflag_mos_lvt=0
parameters totalflag_mos_na25=0
parameters totalflag_mos_na=0
parameters totalflag_mos_uhvt=0
parameters totalflag_mos_ulvt=0
endsection localmconly_mos_moscap

section globalmc_localmc_mos_moscap
setscale options scalefactor=0.9
include "crn28hpcp_lct_2d5_elk_v1d0_2p1.scs" section=tt
include "crn28hpcp_lct_2d5_elk_v1d0_2p1.scs" section=tt_25
include "crn28hpcp_lct_2d5_elk_v1d0_2p1.scs" section=tt_25od33
include "crn28hpcp_lct_2d5_elk_v1d0_2p1.scs" section=tt_25ud18
include "crn28hpcp_lct_2d5_elk_v1d0_2p1.scs" section=tt_ehvt
include "crn28hpcp_lct_2d5_elk_v1d0_2p1.scs" section=tt_hia
include "crn28hpcp_lct_2d5_elk_v1d0_2p1.scs" section=tt_hia25
include "crn28hpcp_lct_2d5_elk_v1d0_2p1.scs" section=tt_hvt
include "crn28hpcp_lct_2d5_elk_v1d0_2p1.scs" section=tt_lvt
include "crn28hpcp_lct_2d5_elk_v1d0_2p1.scs" section=tt_na
include "crn28hpcp_lct_2d5_elk_v1d0_2p1.scs" section=tt_na25
include "crn28hpcp_lct_2d5_elk_v1d0_2p1.scs" section=tt_uhvt
include "crn28hpcp_lct_2d5_elk_v1d0_2p1.scs" section=tt_ulvt
include "crn28hpcp_lct_2d5_elk_v1d0_2p1.scs" section=global
include "crn28hpcp_lct_2d5_elk_v1d0_2p1.scs" section=global_25
include "crn28hpcp_lct_2d5_elk_v1d0_2p1.scs" section=global_25od33
include "crn28hpcp_lct_2d5_elk_v1d0_2p1.scs" section=global_25ud18
include "crn28hpcp_lct_2d5_elk_v1d0_2p1.scs" section=global_ehvt
include "crn28hpcp_lct_2d5_elk_v1d0_2p1.scs" section=global_hvt
include "crn28hpcp_lct_2d5_elk_v1d0_2p1.scs" section=global_lvt
include "crn28hpcp_lct_2d5_elk_v1d0_2p1.scs" section=global_na
include "crn28hpcp_lct_2d5_elk_v1d0_2p1.scs" section=global_na25
include "crn28hpcp_lct_2d5_elk_v1d0_2p1.scs" section=global_uhvt
include "crn28hpcp_lct_2d5_elk_v1d0_2p1.scs" section=global_ulvt
include "crn28hpcp_lct_2d5_elk_v1d0_2p1.scs" section=total
include "crn28hpcp_lct_2d5_elk_v1d0_2p1.scs" section=total_25
include "crn28hpcp_lct_2d5_elk_v1d0_2p1.scs" section=total_25od33
include "crn28hpcp_lct_2d5_elk_v1d0_2p1.scs" section=total_25ud18
include "crn28hpcp_lct_2d5_elk_v1d0_2p1.scs" section=total_ehvt
include "crn28hpcp_lct_2d5_elk_v1d0_2p1.scs" section=total_hvt
include "crn28hpcp_lct_2d5_elk_v1d0_2p1.scs" section=total_lvt
include "crn28hpcp_lct_2d5_elk_v1d0_2p1.scs" section=total_rfmvar
include "crn28hpcp_lct_2d5_elk_v1d0_2p1.scs" section=total_rfmvar_25
include "crn28hpcp_lct_2d5_elk_v1d0_2p1.scs" section=total_mos_cap
include "crn28hpcp_lct_2d5_elk_v1d0_2p1.scs" section=total_mos_cap_25
include "crn28hpcp_lct_2d5_elk_v1d0_2p1.scs" section=total_na
include "crn28hpcp_lct_2d5_elk_v1d0_2p1.scs" section=total_na25
include "crn28hpcp_lct_2d5_elk_v1d0_2p1.scs" section=total_uhvt
include "crn28hpcp_lct_2d5_elk_v1d0_2p1.scs" section=total_ulvt
include "crn28hpcp_lct_2d5_elk_v1d0_2p1.scs" section=stat
parOpt options redefinedparams=ignore
parameters totalflag_mos=0
parameters totalflag_mos_25=0
parameters totalflag_mos_25od33=0
parameters totalflag_mos_25ud18=0
parameters totalflag_mos_ehvt=0
parameters totalflag_mos_hvt=0
parameters totalflag_mos_lvt=0
parameters totalflag_mos_na25=0
parameters totalflag_mos_na=0
parameters totalflag_mos_uhvt=0
parameters totalflag_mos_ulvt=0
endsection globalmc_localmc_mos_moscap

section tt_res_bip_dio_disres
setscale options scalefactor=0.9
include "crn28hpcp_lct_2d5_elk_v1d0_2p1.scs" section=tt_bip
include "crn28hpcp_lct_2d5_elk_v1d0_2p1.scs" section=tt_bip_npn
include "crn28hpcp_lct_2d5_elk_v1d0_2p1.scs" section=tt_dio
include "crn28hpcp_lct_2d5_elk_v1d0_2p1.scs" section=tt_dio_25
include "crn28hpcp_lct_2d5_elk_v1d0_2p1.scs" section=tt_dio_25ll
include "crn28hpcp_lct_2d5_elk_v1d0_2p1.scs" section=tt_dio_25od33
include "crn28hpcp_lct_2d5_elk_v1d0_2p1.scs" section=tt_dio_25ud18
include "crn28hpcp_lct_2d5_elk_v1d0_2p1.scs" section=tt_dio_dnw
include "crn28hpcp_lct_2d5_elk_v1d0_2p1.scs" section=tt_dio_ehvt
include "crn28hpcp_lct_2d5_elk_v1d0_2p1.scs" section=tt_dio_esd
include "crn28hpcp_lct_2d5_elk_v1d0_2p1.scs" section=tt_dio_hia
include "crn28hpcp_lct_2d5_elk_v1d0_2p1.scs" section=tt_dio_hvt
include "crn28hpcp_lct_2d5_elk_v1d0_2p1.scs" section=tt_dio_ll
include "crn28hpcp_lct_2d5_elk_v1d0_2p1.scs" section=tt_dio_lvt
include "crn28hpcp_lct_2d5_elk_v1d0_2p1.scs" section=tt_dio_na
include "crn28hpcp_lct_2d5_elk_v1d0_2p1.scs" section=tt_dio_na25
include "crn28hpcp_lct_2d5_elk_v1d0_2p1.scs" section=tt_dio_uhvt
include "crn28hpcp_lct_2d5_elk_v1d0_2p1.scs" section=tt_dio_ulvt
include "crn28hpcp_lct_2d5_elk_v1d0_2p1.scs" section=tt_disres
include "crn28hpcp_lct_2d5_elk_v1d0_2p1.scs" section=tt_res
parOpt options redefinedparams=ignore
parameters mismatchflag_bip=0
parameters mismatchflag_bip_npn=0
parameters mismatchflag_disres=0
parameters mismatchflag_res=0
endsection tt_res_bip_dio_disres

section ss_res_bip_dio_disres
setscale options scalefactor=0.9
include "crn28hpcp_lct_2d5_elk_v1d0_2p1.scs" section=ss_bip
include "crn28hpcp_lct_2d5_elk_v1d0_2p1.scs" section=ss_bip_npn
include "crn28hpcp_lct_2d5_elk_v1d0_2p1.scs" section=ss_dio
include "crn28hpcp_lct_2d5_elk_v1d0_2p1.scs" section=ss_dio_25
include "crn28hpcp_lct_2d5_elk_v1d0_2p1.scs" section=ss_dio_25ll
include "crn28hpcp_lct_2d5_elk_v1d0_2p1.scs" section=ss_dio_25od33
include "crn28hpcp_lct_2d5_elk_v1d0_2p1.scs" section=ss_dio_25ud18
include "crn28hpcp_lct_2d5_elk_v1d0_2p1.scs" section=ss_dio_dnw
include "crn28hpcp_lct_2d5_elk_v1d0_2p1.scs" section=ss_dio_ehvt
include "crn28hpcp_lct_2d5_elk_v1d0_2p1.scs" section=ss_dio_esd
include "crn28hpcp_lct_2d5_elk_v1d0_2p1.scs" section=ss_dio_hia
include "crn28hpcp_lct_2d5_elk_v1d0_2p1.scs" section=ss_dio_hvt
include "crn28hpcp_lct_2d5_elk_v1d0_2p1.scs" section=ss_dio_ll
include "crn28hpcp_lct_2d5_elk_v1d0_2p1.scs" section=ss_dio_lvt
include "crn28hpcp_lct_2d5_elk_v1d0_2p1.scs" section=ss_dio_na
include "crn28hpcp_lct_2d5_elk_v1d0_2p1.scs" section=ss_dio_na25
include "crn28hpcp_lct_2d5_elk_v1d0_2p1.scs" section=ss_dio_uhvt
include "crn28hpcp_lct_2d5_elk_v1d0_2p1.scs" section=ss_dio_ulvt
include "crn28hpcp_lct_2d5_elk_v1d0_2p1.scs" section=ss_disres
include "crn28hpcp_lct_2d5_elk_v1d0_2p1.scs" section=ss_res
parOpt options redefinedparams=ignore
parameters mismatchflag_bip=0
parameters mismatchflag_bip_npn=0
parameters mismatchflag_disres=0
parameters mismatchflag_res=0
endsection ss_res_bip_dio_disres

section ff_res_bip_dio_disres
setscale options scalefactor=0.9
include "crn28hpcp_lct_2d5_elk_v1d0_2p1.scs" section=ff_bip
include "crn28hpcp_lct_2d5_elk_v1d0_2p1.scs" section=ff_bip_npn
include "crn28hpcp_lct_2d5_elk_v1d0_2p1.scs" section=ff_dio
include "crn28hpcp_lct_2d5_elk_v1d0_2p1.scs" section=ff_dio_25
include "crn28hpcp_lct_2d5_elk_v1d0_2p1.scs" section=ff_dio_25ll
include "crn28hpcp_lct_2d5_elk_v1d0_2p1.scs" section=ff_dio_25od33
include "crn28hpcp_lct_2d5_elk_v1d0_2p1.scs" section=ff_dio_25ud18
include "crn28hpcp_lct_2d5_elk_v1d0_2p1.scs" section=ff_dio_dnw
include "crn28hpcp_lct_2d5_elk_v1d0_2p1.scs" section=ff_dio_ehvt
include "crn28hpcp_lct_2d5_elk_v1d0_2p1.scs" section=ff_dio_esd
include "crn28hpcp_lct_2d5_elk_v1d0_2p1.scs" section=ff_dio_hia
include "crn28hpcp_lct_2d5_elk_v1d0_2p1.scs" section=ff_dio_hvt
include "crn28hpcp_lct_2d5_elk_v1d0_2p1.scs" section=ff_dio_ll
include "crn28hpcp_lct_2d5_elk_v1d0_2p1.scs" section=ff_dio_lvt
include "crn28hpcp_lct_2d5_elk_v1d0_2p1.scs" section=ff_dio_na
include "crn28hpcp_lct_2d5_elk_v1d0_2p1.scs" section=ff_dio_na25
include "crn28hpcp_lct_2d5_elk_v1d0_2p1.scs" section=ff_dio_uhvt
include "crn28hpcp_lct_2d5_elk_v1d0_2p1.scs" section=ff_dio_ulvt
include "crn28hpcp_lct_2d5_elk_v1d0_2p1.scs" section=ff_disres
include "crn28hpcp_lct_2d5_elk_v1d0_2p1.scs" section=ff_res
parOpt options redefinedparams=ignore
parameters mismatchflag_bip=0
parameters mismatchflag_bip_npn=0
parameters mismatchflag_disres=0
parameters mismatchflag_res=0
endsection ff_res_bip_dio_disres

section ttglobalcorner_localmc_res_bip_dio_disres
setscale options scalefactor=0.9
include "crn28hpcp_lct_2d5_elk_v1d0_2p1.scs" section=tt_bip
include "crn28hpcp_lct_2d5_elk_v1d0_2p1.scs" section=tt_bip_npn
include "crn28hpcp_lct_2d5_elk_v1d0_2p1.scs" section=tt_dio
include "crn28hpcp_lct_2d5_elk_v1d0_2p1.scs" section=tt_dio_25
include "crn28hpcp_lct_2d5_elk_v1d0_2p1.scs" section=tt_dio_25ll
include "crn28hpcp_lct_2d5_elk_v1d0_2p1.scs" section=tt_dio_25od33
include "crn28hpcp_lct_2d5_elk_v1d0_2p1.scs" section=tt_dio_25ud18
include "crn28hpcp_lct_2d5_elk_v1d0_2p1.scs" section=tt_dio_dnw
include "crn28hpcp_lct_2d5_elk_v1d0_2p1.scs" section=tt_dio_ehvt
include "crn28hpcp_lct_2d5_elk_v1d0_2p1.scs" section=tt_dio_esd
include "crn28hpcp_lct_2d5_elk_v1d0_2p1.scs" section=tt_dio_hia
include "crn28hpcp_lct_2d5_elk_v1d0_2p1.scs" section=tt_dio_hvt
include "crn28hpcp_lct_2d5_elk_v1d0_2p1.scs" section=tt_dio_ll
include "crn28hpcp_lct_2d5_elk_v1d0_2p1.scs" section=tt_dio_lvt
include "crn28hpcp_lct_2d5_elk_v1d0_2p1.scs" section=tt_dio_na
include "crn28hpcp_lct_2d5_elk_v1d0_2p1.scs" section=tt_dio_na25
include "crn28hpcp_lct_2d5_elk_v1d0_2p1.scs" section=tt_dio_uhvt
include "crn28hpcp_lct_2d5_elk_v1d0_2p1.scs" section=tt_dio_ulvt
include "crn28hpcp_lct_2d5_elk_v1d0_2p1.scs" section=tt_disres
include "crn28hpcp_lct_2d5_elk_v1d0_2p1.scs" section=tt_res
include "crn28hpcp_lct_2d5_elk_v1d0_2p1.scs" section=stat_mis_bip
include "crn28hpcp_lct_2d5_elk_v1d0_2p1.scs" section=stat_mis_bip_npn
include "crn28hpcp_lct_2d5_elk_v1d0_2p1.scs" section=stat_mis_disres
include "crn28hpcp_lct_2d5_elk_v1d0_2p1.scs" section=stat_mis_res
endsection ttglobalcorner_localmc_res_bip_dio_disres

section ssglobalcorner_localmc_res_bip_dio_disres
setscale options scalefactor=0.9
include "crn28hpcp_lct_2d5_elk_v1d0_2p1.scs" section=ss_bip
include "crn28hpcp_lct_2d5_elk_v1d0_2p1.scs" section=ss_bip_npn
include "crn28hpcp_lct_2d5_elk_v1d0_2p1.scs" section=ss_dio
include "crn28hpcp_lct_2d5_elk_v1d0_2p1.scs" section=ss_dio_25
include "crn28hpcp_lct_2d5_elk_v1d0_2p1.scs" section=ss_dio_25ll
include "crn28hpcp_lct_2d5_elk_v1d0_2p1.scs" section=ss_dio_25od33
include "crn28hpcp_lct_2d5_elk_v1d0_2p1.scs" section=ss_dio_25ud18
include "crn28hpcp_lct_2d5_elk_v1d0_2p1.scs" section=ss_dio_dnw
include "crn28hpcp_lct_2d5_elk_v1d0_2p1.scs" section=ss_dio_ehvt
include "crn28hpcp_lct_2d5_elk_v1d0_2p1.scs" section=ss_dio_esd
include "crn28hpcp_lct_2d5_elk_v1d0_2p1.scs" section=ss_dio_hia
include "crn28hpcp_lct_2d5_elk_v1d0_2p1.scs" section=ss_dio_hvt
include "crn28hpcp_lct_2d5_elk_v1d0_2p1.scs" section=ss_dio_ll
include "crn28hpcp_lct_2d5_elk_v1d0_2p1.scs" section=ss_dio_lvt
include "crn28hpcp_lct_2d5_elk_v1d0_2p1.scs" section=ss_dio_na
include "crn28hpcp_lct_2d5_elk_v1d0_2p1.scs" section=ss_dio_na25
include "crn28hpcp_lct_2d5_elk_v1d0_2p1.scs" section=ss_dio_uhvt
include "crn28hpcp_lct_2d5_elk_v1d0_2p1.scs" section=ss_dio_ulvt
include "crn28hpcp_lct_2d5_elk_v1d0_2p1.scs" section=ss_disres
include "crn28hpcp_lct_2d5_elk_v1d0_2p1.scs" section=ss_res
include "crn28hpcp_lct_2d5_elk_v1d0_2p1.scs" section=stat_mis_bip
include "crn28hpcp_lct_2d5_elk_v1d0_2p1.scs" section=stat_mis_bip_npn
include "crn28hpcp_lct_2d5_elk_v1d0_2p1.scs" section=stat_mis_disres
include "crn28hpcp_lct_2d5_elk_v1d0_2p1.scs" section=stat_mis_res
endsection ssglobalcorner_localmc_res_bip_dio_disres

section ffglobalcorner_localmc_res_bip_dio_disres
setscale options scalefactor=0.9
include "crn28hpcp_lct_2d5_elk_v1d0_2p1.scs" section=ff_bip
include "crn28hpcp_lct_2d5_elk_v1d0_2p1.scs" section=ff_bip_npn
include "crn28hpcp_lct_2d5_elk_v1d0_2p1.scs" section=ff_dio
include "crn28hpcp_lct_2d5_elk_v1d0_2p1.scs" section=ff_dio_25
include "crn28hpcp_lct_2d5_elk_v1d0_2p1.scs" section=ff_dio_25ll
include "crn28hpcp_lct_2d5_elk_v1d0_2p1.scs" section=ff_dio_25od33
include "crn28hpcp_lct_2d5_elk_v1d0_2p1.scs" section=ff_dio_25ud18
include "crn28hpcp_lct_2d5_elk_v1d0_2p1.scs" section=ff_dio_dnw
include "crn28hpcp_lct_2d5_elk_v1d0_2p1.scs" section=ff_dio_ehvt
include "crn28hpcp_lct_2d5_elk_v1d0_2p1.scs" section=ff_dio_esd
include "crn28hpcp_lct_2d5_elk_v1d0_2p1.scs" section=ff_dio_hia
include "crn28hpcp_lct_2d5_elk_v1d0_2p1.scs" section=ff_dio_hvt
include "crn28hpcp_lct_2d5_elk_v1d0_2p1.scs" section=ff_dio_ll
include "crn28hpcp_lct_2d5_elk_v1d0_2p1.scs" section=ff_dio_lvt
include "crn28hpcp_lct_2d5_elk_v1d0_2p1.scs" section=ff_dio_na
include "crn28hpcp_lct_2d5_elk_v1d0_2p1.scs" section=ff_dio_na25
include "crn28hpcp_lct_2d5_elk_v1d0_2p1.scs" section=ff_dio_uhvt
include "crn28hpcp_lct_2d5_elk_v1d0_2p1.scs" section=ff_dio_ulvt
include "crn28hpcp_lct_2d5_elk_v1d0_2p1.scs" section=ff_disres
include "crn28hpcp_lct_2d5_elk_v1d0_2p1.scs" section=ff_res
include "crn28hpcp_lct_2d5_elk_v1d0_2p1.scs" section=stat_mis_bip
include "crn28hpcp_lct_2d5_elk_v1d0_2p1.scs" section=stat_mis_bip_npn
include "crn28hpcp_lct_2d5_elk_v1d0_2p1.scs" section=stat_mis_disres
include "crn28hpcp_lct_2d5_elk_v1d0_2p1.scs" section=stat_mis_res
endsection ffglobalcorner_localmc_res_bip_dio_disres

section localmconly_res_bip_dio_disres
setscale options scalefactor=0.9
include "crn28hpcp_lct_2d5_elk_v1d0_2p1.scs" section=tt_bip
include "crn28hpcp_lct_2d5_elk_v1d0_2p1.scs" section=tt_bip_npn
include "crn28hpcp_lct_2d5_elk_v1d0_2p1.scs" section=tt_dio
include "crn28hpcp_lct_2d5_elk_v1d0_2p1.scs" section=tt_dio_25
include "crn28hpcp_lct_2d5_elk_v1d0_2p1.scs" section=tt_dio_25ll
include "crn28hpcp_lct_2d5_elk_v1d0_2p1.scs" section=tt_dio_25od33
include "crn28hpcp_lct_2d5_elk_v1d0_2p1.scs" section=tt_dio_25ud18
include "crn28hpcp_lct_2d5_elk_v1d0_2p1.scs" section=tt_dio_dnw
include "crn28hpcp_lct_2d5_elk_v1d0_2p1.scs" section=tt_dio_ehvt
include "crn28hpcp_lct_2d5_elk_v1d0_2p1.scs" section=tt_dio_esd
include "crn28hpcp_lct_2d5_elk_v1d0_2p1.scs" section=tt_dio_hia
include "crn28hpcp_lct_2d5_elk_v1d0_2p1.scs" section=tt_dio_hvt
include "crn28hpcp_lct_2d5_elk_v1d0_2p1.scs" section=tt_dio_ll
include "crn28hpcp_lct_2d5_elk_v1d0_2p1.scs" section=tt_dio_lvt
include "crn28hpcp_lct_2d5_elk_v1d0_2p1.scs" section=tt_dio_na
include "crn28hpcp_lct_2d5_elk_v1d0_2p1.scs" section=tt_dio_na25
include "crn28hpcp_lct_2d5_elk_v1d0_2p1.scs" section=tt_dio_uhvt
include "crn28hpcp_lct_2d5_elk_v1d0_2p1.scs" section=tt_dio_ulvt
include "crn28hpcp_lct_2d5_elk_v1d0_2p1.scs" section=tt_disres
include "crn28hpcp_lct_2d5_elk_v1d0_2p1.scs" section=tt_res
include "crn28hpcp_lct_2d5_elk_v1d0_2p1.scs" section=stat_mis_bip
include "crn28hpcp_lct_2d5_elk_v1d0_2p1.scs" section=stat_mis_bip_npn
include "crn28hpcp_lct_2d5_elk_v1d0_2p1.scs" section=stat_mis_disres
include "crn28hpcp_lct_2d5_elk_v1d0_2p1.scs" section=stat_mis_res
endsection localmconly_res_bip_dio_disres

section globalmc_localmc_res_bip_dio_disres
setscale options scalefactor=0.9
include "crn28hpcp_lct_2d5_elk_v1d0_2p1.scs" section=tt_dio_hia
include "crn28hpcp_lct_2d5_elk_v1d0_2p1.scs" section=total_bip
include "crn28hpcp_lct_2d5_elk_v1d0_2p1.scs" section=total_bip_npn
include "crn28hpcp_lct_2d5_elk_v1d0_2p1.scs" section=total_dio
include "crn28hpcp_lct_2d5_elk_v1d0_2p1.scs" section=total_dio_25
include "crn28hpcp_lct_2d5_elk_v1d0_2p1.scs" section=total_dio_25ll
include "crn28hpcp_lct_2d5_elk_v1d0_2p1.scs" section=total_dio_25od33
include "crn28hpcp_lct_2d5_elk_v1d0_2p1.scs" section=total_dio_25ud18
include "crn28hpcp_lct_2d5_elk_v1d0_2p1.scs" section=total_dio_dnw
include "crn28hpcp_lct_2d5_elk_v1d0_2p1.scs" section=total_dio_ehvt
include "crn28hpcp_lct_2d5_elk_v1d0_2p1.scs" section=total_dio_esd
include "crn28hpcp_lct_2d5_elk_v1d0_2p1.scs" section=total_dio_hvt
include "crn28hpcp_lct_2d5_elk_v1d0_2p1.scs" section=total_dio_ll
include "crn28hpcp_lct_2d5_elk_v1d0_2p1.scs" section=total_dio_lvt
include "crn28hpcp_lct_2d5_elk_v1d0_2p1.scs" section=total_dio_na
include "crn28hpcp_lct_2d5_elk_v1d0_2p1.scs" section=total_dio_na25
include "crn28hpcp_lct_2d5_elk_v1d0_2p1.scs" section=total_dio_uhvt
include "crn28hpcp_lct_2d5_elk_v1d0_2p1.scs" section=total_dio_ulvt
include "crn28hpcp_lct_2d5_elk_v1d0_2p1.scs" section=total_disres
include "crn28hpcp_lct_2d5_elk_v1d0_2p1.scs" section=total_res
include "crn28hpcp_lct_2d5_elk_v1d0_2p1.scs" section=stat_bip_dio
include "crn28hpcp_lct_2d5_elk_v1d0_2p1.scs" section=stat_mis_bip
include "crn28hpcp_lct_2d5_elk_v1d0_2p1.scs" section=stat_mis_bip_npn
include "crn28hpcp_lct_2d5_elk_v1d0_2p1.scs" section=stat_mis_disres
include "crn28hpcp_lct_2d5_elk_v1d0_2p1.scs" section=stat_mis_res
include "crn28hpcp_lct_2d5_elk_v1d0_2p1.scs" section=stat_res
endsection globalmc_localmc_res_bip_dio_disres

section tt_mom
setscale options scalefactor=0.9
include "crn28hpcp_lct_2d5_elk_v1d0_2p1.scs" section=tt_rffmom
include "crn28hpcp_lct_2d5_elk_v1d0_2p1.scs" section=tt_fmom
parOpt options redefinedparams=ignore
parameters mismatchflag_fmom=0
parameters mismatchflag_rffmom=0
endsection tt_mom

section ss_mom
setscale options scalefactor=0.9
include "crn28hpcp_lct_2d5_elk_v1d0_2p1.scs" section=ss_rffmom
include "crn28hpcp_lct_2d5_elk_v1d0_2p1.scs" section=ss_fmom
parOpt options redefinedparams=ignore
parameters mismatchflag_fmom=0
parameters mismatchflag_rffmom=0
endsection ss_mom

section ff_mom
setscale options scalefactor=0.9
include "crn28hpcp_lct_2d5_elk_v1d0_2p1.scs" section=ff_rffmom
include "crn28hpcp_lct_2d5_elk_v1d0_2p1.scs" section=ff_fmom
parOpt options redefinedparams=ignore
parameters mismatchflag_fmom=0
parameters mismatchflag_rffmom=0
endsection ff_mom

section ttglobalcorner_localmc_mom
setscale options scalefactor=0.9
include "crn28hpcp_lct_2d5_elk_v1d0_2p1.scs" section=tt_rffmom
include "crn28hpcp_lct_2d5_elk_v1d0_2p1.scs" section=stat_mis_rffmom
include "crn28hpcp_lct_2d5_elk_v1d0_2p1.scs" section=tt_fmom
include "crn28hpcp_lct_2d5_elk_v1d0_2p1.scs" section=stat_mis_fmom
endsection ttglobalcorner_localmc_mom

section ssglobalcorner_localmc_mom
setscale options scalefactor=0.9
include "crn28hpcp_lct_2d5_elk_v1d0_2p1.scs" section=ss_rffmom
include "crn28hpcp_lct_2d5_elk_v1d0_2p1.scs" section=stat_mis_rffmom
include "crn28hpcp_lct_2d5_elk_v1d0_2p1.scs" section=ss_fmom
include "crn28hpcp_lct_2d5_elk_v1d0_2p1.scs" section=stat_mis_fmom
endsection ssglobalcorner_localmc_mom

section ffglobalcorner_localmc_mom
setscale options scalefactor=0.9
include "crn28hpcp_lct_2d5_elk_v1d0_2p1.scs" section=ff_rffmom
include "crn28hpcp_lct_2d5_elk_v1d0_2p1.scs" section=stat_mis_rffmom
include "crn28hpcp_lct_2d5_elk_v1d0_2p1.scs" section=ff_fmom
include "crn28hpcp_lct_2d5_elk_v1d0_2p1.scs" section=stat_mis_fmom
endsection ffglobalcorner_localmc_mom

section localmconly_mom
setscale options scalefactor=0.9
include "crn28hpcp_lct_2d5_elk_v1d0_2p1.scs" section=tt_rffmom
include "crn28hpcp_lct_2d5_elk_v1d0_2p1.scs" section=tt_fmom
include "crn28hpcp_lct_2d5_elk_v1d0_2p1.scs" section=stat_mis_rffmom
include "crn28hpcp_lct_2d5_elk_v1d0_2p1.scs" section=stat_mis_fmom
endsection localmconly_mom

section globalmc_localmc_mom
setscale options scalefactor=0.9
include "crn28hpcp_lct_2d5_elk_v1d0_2p1.scs" section=total_rffmom
include "crn28hpcp_lct_2d5_elk_v1d0_2p1.scs" section=total_fmom
include "crn28hpcp_lct_2d5_elk_v1d0_2p1.scs" section=stat_mis_fmom
include "crn28hpcp_lct_2d5_elk_v1d0_2p1.scs" section=stat_mis_rffmom
include "crn28hpcp_lct_2d5_elk_v1d0_2p1.scs" section=stat_mom
endsection globalmc_localmc_mom

section tt_r_metal
setscale options scalefactor=0.9
include "res_metal.scs" section=tt_res_metal
endsection tt_r_metal

section ss_r_metal
setscale options scalefactor=0.9
include "res_metal.scs" section=ss_res_metal
endsection ss_r_metal

section ff_r_metal
setscale options scalefactor=0.9
include "res_metal.scs" section=ff_res_metal
endsection ff_r_metal
