//
simulator lang=spectre insensitive=yes
library tsmclib
//   *       TSMC SPICE MODEL --- Security B --- TSMC Restricted Secret      *
//   *************************************************************************
//     PROCESS :  0.028um LOGIC (1P10M_7X2Z +UT-ALRDL) ELK-IMD (CLN28ULP)
//     MODEL   :  BSIM4 ( V4.5 )
//     VERSION :  V0.1_1p2
//     DATE    :  10:36AM, Nov. 14, 2014
//     SPECTRE VERSION : 11.1.0.249
// ***************************************************************************************************
//
//   1.LIB TT_res_metal
//                         *
//         SS_res_metal
//                         *
//         FF_res_metal
//                         *
//     (Metal resistance)
//                      *
// ***************************************************************************************************
//

section setup_res_metal
parameters factor_res_metal=0.9
endsection setup_res_metal

// *************************************************************************
//
//    RESISTANCE MODEL
//
// *************************************************************************

section tt_res_metal
include "res_metal.scs" section=setup_res_metal
parameters r_rm1l=0.2153
parameters r_rm1s=0.45
parameters r_rm1w=0.4675
parameters r_rm2l=0.195
parameters r_rm2s=0.45
parameters r_rm2w=0.3967
parameters r_rm3l=0.195
parameters r_rm3s=0.45
parameters r_rm3w=0.3967
parameters r_rm4l=0.195
parameters r_rm4s=0.45
parameters r_rm4w=0.3967
parameters r_rm5l=0.195
parameters r_rm5s=0.45
parameters r_rm5w=0.3967
parameters r_rm6l=0.195
parameters r_rm6s=0.45
parameters r_rm6w=0.3967
parameters r_rm7l=0.195
parameters r_rm7s=0.45
parameters r_rm7w=0.3967
parameters r_rm8l=0.195
parameters r_rm8s=0.45
parameters r_rm8w=0.3967
parameters r_rm9l=0.0221
parameters r_rm9s=0.022
parameters r_rm9w=0.0229
parameters r_rm10l=0.0221
parameters r_rm10s=0.022
parameters r_rm10w=0.0229
parameters r_rmap=0.011
parameters r_rmxl=0.195
parameters r_rmxs=0.45
parameters r_rmxw=0.3967
parameters r_rmzl=0.0221
parameters r_rmzs=0.022
parameters r_rmzw=0.0229
include "res_metal.scs" section=res_metal
endsection tt_res_metal

section ss_res_metal
include "res_metal.scs" section=setup_res_metal
parameters r_rm1l=0.2153 * 1.26
parameters r_rm1s=0.45 * 1.29
parameters r_rm1w=0.4675 * 1.25
parameters r_rm2l=0.195 * 1.28
parameters r_rm2s=0.45 * 1.31
parameters r_rm2w=0.3967 * 1.26
parameters r_rm3l=0.195 * 1.28
parameters r_rm3s=0.45 * 1.31
parameters r_rm3w=0.3967 * 1.26
parameters r_rm4l=0.195 * 1.28
parameters r_rm4s=0.45 * 1.31
parameters r_rm4w=0.3967 * 1.26
parameters r_rm5l=0.195 * 1.28
parameters r_rm5s=0.45 * 1.31
parameters r_rm5w=0.3967 * 1.26
parameters r_rm6l=0.195 * 1.28
parameters r_rm6s=0.45 * 1.31
parameters r_rm6w=0.3967 * 1.26
parameters r_rm7l=0.195 * 1.28
parameters r_rm7s=0.45 * 1.31
parameters r_rm7w=0.3967 * 1.26
parameters r_rm8l=0.195 * 1.28
parameters r_rm8s=0.45 * 1.31
parameters r_rm8w=0.3967 * 1.26
parameters r_rm9l=0.0221 * 1.19
parameters r_rm9s=0.022 * 1.2
parameters r_rm9w=0.0229 * 1.14
parameters r_rm10l=0.0221 * 1.19
parameters r_rm10s=0.022 * 1.2
parameters r_rm10w=0.0229 * 1.14
parameters r_rmap=0.011 * 1.2
parameters r_rmxl=0.195 * 1.28
parameters r_rmxs=0.45 * 1.31
parameters r_rmxw=0.3967 * 1.26
parameters r_rmzl=0.0221 * 1.19
parameters r_rmzs=0.022 * 1.2
parameters r_rmzw=0.0229 * 1.14
include "res_metal.scs" section=res_metal
endsection ss_res_metal

section ff_res_metal
include "res_metal.scs" section=setup_res_metal
parameters r_rm1l=0.2153 * 0.81
parameters r_rm1s=0.45 * 0.8
parameters r_rm1w=0.4675 * 0.82
parameters r_rm2l=0.195 * 0.8
parameters r_rm2s=0.45 * 0.79
parameters r_rm2w=0.3967 * 0.82
parameters r_rm3l=0.195 * 0.8
parameters r_rm3s=0.45 * 0.79
parameters r_rm3w=0.3967 * 0.82
parameters r_rm4l=0.195 * 0.8
parameters r_rm4s=0.45 * 0.79
parameters r_rm4w=0.3967 * 0.82
parameters r_rm5l=0.195 * 0.8
parameters r_rm5s=0.45 * 0.79
parameters r_rm5w=0.3967 * 0.82
parameters r_rm6l=0.195 * 0.8
parameters r_rm6s=0.45 * 0.79
parameters r_rm6w=0.3967 * 0.82
parameters r_rm7l=0.195 * 0.8
parameters r_rm7s=0.45 * 0.79
parameters r_rm7w=0.3967 * 0.82
parameters r_rm8l=0.195 * 0.8
parameters r_rm8s=0.45 * 0.79
parameters r_rm8w=0.3967 * 0.82
parameters r_rm9l=0.0221 * 0.85
parameters r_rm9s=0.022 * 0.84
parameters r_rm9w=0.0229 * 0.89
parameters r_rm10l=0.0221 * 0.85
parameters r_rm10s=0.022 * 0.84
parameters r_rm10w=0.0229 * 0.89
parameters r_rmap=0.011 * 0.8
parameters r_rmxl=0.195 * 0.8
parameters r_rmxs=0.45 * 0.79
parameters r_rmxw=0.3967 * 0.82
parameters r_rmzl=0.0221 * 0.85
parameters r_rmzs=0.022 * 0.84
parameters r_rmzw=0.0229 * 0.89
include "res_metal.scs" section=res_metal
endsection ff_res_metal

section res_metal

// **********************************     Metal 1 with W/S=0.045/0.135     ***********************************
subckt rm1l ( n1 n2 )
parameters l=1u w=1u factor=factor_res_metal multi=1 rsh=r_rm1l dw=0 pvc1=0
+ pvc2=0 ptc1=1.78e-03 ptc2=-1.94e-07 pt=temp tfac=1.0 + ptc1 * (pt - 25.0) +
+ ptc2 * (pt - 25.0) * (pt - 25.0)
r1 ( n1 n2 ) resistor r=rsh / multi * l * factor / (w * factor - dw) * (1 + pvc1
+ * (abs(v(n2,n1)) / l / factor) + pvc2 * (v(n2,n1) / l / factor) * (v(n2,n1) /
+ l / factor)) * tfac
ends rm1l

// **********************************     Metal 1 with W/S=0.045/0.045     ***********************************
subckt rm1s ( n1 n2 )
parameters l=1u w=1u factor=factor_res_metal multi=1 rsh=r_rm1s dw=0 pvc1=0
+ pvc2=0 ptc1=1.75e-03 ptc2=-3.73e-07 pt=temp tfac=1.0 + ptc1 * (pt - 25.0) +
+ ptc2 * (pt - 25.0) * (pt - 25.0)
r1 ( n1 n2 ) resistor r=rsh / multi * l * factor / (w * factor - dw) * (1 + pvc1
+ * (abs(v(n2,n1)) / l / factor) + pvc2 * (v(n2,n1) / l / factor) * (v(n2,n1) /
+ l / factor)) * tfac
ends rm1s

// **********************************     Metal 1 with W/S=0.135/0.045     ***********************************
subckt rm1w ( n1 n2 )
parameters l=1u w=1u factor=factor_res_metal multi=1 rsh=r_rm1w dw=0 pvc1=0
+ pvc2=0 ptc1=1.83e-03 ptc2=-2.05e-07 pt=temp tfac=1.0 + ptc1 * (pt - 25.0) +
+ ptc2 * (pt - 25.0) * (pt - 25.0)
r1 ( n1 n2 ) resistor r=rsh / multi * l * factor / (w * factor - dw) * (1 + pvc1
+ * (abs(v(n2,n1)) / l / factor) + pvc2 * (v(n2,n1) / l / factor) * (v(n2,n1) /
+ l / factor)) * tfac
ends rm1w

// **********************************     Metal 2 with W/S=0.045/0.135     ***********************************
subckt rm2l ( n1 n2 )
parameters l=1u w=1u factor=factor_res_metal multi=1 rsh=r_rm2l dw=0 pvc1=0
+ pvc2=0 ptc1=2.02e-03 ptc2=-2.80e-07 pt=temp tfac=1.0 + ptc1 * (pt - 25.0) +
+ ptc2 * (pt - 25.0) * (pt - 25.0)
r1 ( n1 n2 ) resistor r=rsh / multi * l * factor / (w * factor - dw) * (1 + pvc1
+ * (abs(v(n2,n1)) / l / factor) + pvc2 * (v(n2,n1) / l / factor) * (v(n2,n1) /
+ l / factor)) * tfac
ends rm2l

// **********************************     Metal 2 with W/S=0.045/0.045     ***********************************
subckt rm2s ( n1 n2 )
parameters l=1u w=1u factor=factor_res_metal multi=1 rsh=r_rm2s dw=0 pvc1=0
+ pvc2=0 ptc1=1.94e-03 ptc2=-4.64e-07 pt=temp tfac=1.0 + ptc1 * (pt - 25.0) +
+ ptc2 * (pt - 25.0) * (pt - 25.0)
r1 ( n1 n2 ) resistor r=rsh / multi * l * factor / (w * factor - dw) * (1 + pvc1
+ * (abs(v(n2,n1)) / l / factor) + pvc2 * (v(n2,n1) / l / factor) * (v(n2,n1) /
+ l / factor)) * tfac
ends rm2s

// **********************************     Metal 2 with W/S=0.135/0.045     ***********************************
subckt rm2w ( n1 n2 )
parameters l=1u w=1u factor=factor_res_metal multi=1 rsh=r_rm2w dw=0 pvc1=0
+ pvc2=0 ptc1=2.04e-03 ptc2=-2.50e-07 pt=temp tfac=1.0 + ptc1 * (pt - 25.0) +
+ ptc2 * (pt - 25.0) * (pt - 25.0)
r1 ( n1 n2 ) resistor r=rsh / multi * l * factor / (w * factor - dw) * (1 + pvc1
+ * (abs(v(n2,n1)) / l / factor) + pvc2 * (v(n2,n1) / l / factor) * (v(n2,n1) /
+ l / factor)) * tfac
ends rm2w

// **********************************     Metal 3 with W/S=0.045/0.135     ***********************************
subckt rm3l ( n1 n2 )
parameters l=1u w=1u factor=factor_res_metal multi=1 rsh=r_rm3l dw=0 pvc1=0
+ pvc2=0 ptc1=2.02e-03 ptc2=-2.80e-07 pt=temp tfac=1.0 + ptc1 * (pt - 25.0) +
+ ptc2 * (pt - 25.0) * (pt - 25.0)
r1 ( n1 n2 ) resistor r=rsh / multi * l * factor / (w * factor - dw) * (1 + pvc1
+ * (abs(v(n2,n1)) / l / factor) + pvc2 * (v(n2,n1) / l / factor) * (v(n2,n1) /
+ l / factor)) * tfac
ends rm3l

// **********************************     Metal 3 with W/S=0.045/0.045     ***********************************
subckt rm3s ( n1 n2 )
parameters l=1u w=1u factor=factor_res_metal multi=1 rsh=r_rm3s dw=0 pvc1=0
+ pvc2=0 ptc1=1.94e-03 ptc2=-4.64e-07 pt=temp tfac=1.0 + ptc1 * (pt - 25.0) +
+ ptc2 * (pt - 25.0) * (pt - 25.0)
r1 ( n1 n2 ) resistor r=rsh / multi * l * factor / (w * factor - dw) * (1 + pvc1
+ * (abs(v(n2,n1)) / l / factor) + pvc2 * (v(n2,n1) / l / factor) * (v(n2,n1) /
+ l / factor)) * tfac
ends rm3s

// **********************************     Metal 3 with W/S=0.135/0.045     ***********************************
subckt rm3w ( n1 n2 )
parameters l=1u w=1u factor=factor_res_metal multi=1 rsh=r_rm3w dw=0 pvc1=0
+ pvc2=0 ptc1=2.04e-03 ptc2=-2.50e-07 pt=temp tfac=1.0 + ptc1 * (pt - 25.0) +
+ ptc2 * (pt - 25.0) * (pt - 25.0)
r1 ( n1 n2 ) resistor r=rsh / multi * l * factor / (w * factor - dw) * (1 + pvc1
+ * (abs(v(n2,n1)) / l / factor) + pvc2 * (v(n2,n1) / l / factor) * (v(n2,n1) /
+ l / factor)) * tfac
ends rm3w

// **********************************     Metal 4 with W/S=0.045/0.135     ***********************************
subckt rm4l ( n1 n2 )
parameters l=1u w=1u factor=factor_res_metal multi=1 rsh=r_rm4l dw=0 pvc1=0
+ pvc2=0 ptc1=2.02e-03 ptc2=-2.80e-07 pt=temp tfac=1.0 + ptc1 * (pt - 25.0) +
+ ptc2 * (pt - 25.0) * (pt - 25.0)
r1 ( n1 n2 ) resistor r=rsh / multi * l * factor / (w * factor - dw) * (1 + pvc1
+ * (abs(v(n2,n1)) / l / factor) + pvc2 * (v(n2,n1) / l / factor) * (v(n2,n1) /
+ l / factor)) * tfac
ends rm4l

// **********************************     Metal 4 with W/S=0.045/0.045     ***********************************
subckt rm4s ( n1 n2 )
parameters l=1u w=1u factor=factor_res_metal multi=1 rsh=r_rm4s dw=0 pvc1=0
+ pvc2=0 ptc1=1.94e-03 ptc2=-4.64e-07 pt=temp tfac=1.0 + ptc1 * (pt - 25.0) +
+ ptc2 * (pt - 25.0) * (pt - 25.0)
r1 ( n1 n2 ) resistor r=rsh / multi * l * factor / (w * factor - dw) * (1 + pvc1
+ * (abs(v(n2,n1)) / l / factor) + pvc2 * (v(n2,n1) / l / factor) * (v(n2,n1) /
+ l / factor)) * tfac
ends rm4s

// **********************************     Metal 4 with W/S=0.135/0.045     ***********************************
subckt rm4w ( n1 n2 )
parameters l=1u w=1u factor=factor_res_metal multi=1 rsh=r_rm4w dw=0 pvc1=0
+ pvc2=0 ptc1=2.04e-03 ptc2=-2.50e-07 pt=temp tfac=1.0 + ptc1 * (pt - 25.0) +
+ ptc2 * (pt - 25.0) * (pt - 25.0)
r1 ( n1 n2 ) resistor r=rsh / multi * l * factor / (w * factor - dw) * (1 + pvc1
+ * (abs(v(n2,n1)) / l / factor) + pvc2 * (v(n2,n1) / l / factor) * (v(n2,n1) /
+ l / factor)) * tfac
ends rm4w

// **********************************     Metal 5 with W/S=0.045/0.135     ***********************************
subckt rm5l ( n1 n2 )
parameters l=1u w=1u factor=factor_res_metal multi=1 rsh=r_rm5l dw=0 pvc1=0
+ pvc2=0 ptc1=2.02e-03 ptc2=-2.80e-07 pt=temp tfac=1.0 + ptc1 * (pt - 25.0) +
+ ptc2 * (pt - 25.0) * (pt - 25.0)
r1 ( n1 n2 ) resistor r=rsh / multi * l * factor / (w * factor - dw) * (1 + pvc1
+ * (abs(v(n2,n1)) / l / factor) + pvc2 * (v(n2,n1) / l / factor) * (v(n2,n1) /
+ l / factor)) * tfac
ends rm5l

// **********************************     Metal 5 with W/S=0.045/0.045     ***********************************
subckt rm5s ( n1 n2 )
parameters l=1u w=1u factor=factor_res_metal multi=1 rsh=r_rm5s dw=0 pvc1=0
+ pvc2=0 ptc1=1.94e-03 ptc2=-4.64e-07 pt=temp tfac=1.0 + ptc1 * (pt - 25.0) +
+ ptc2 * (pt - 25.0) * (pt - 25.0)
r1 ( n1 n2 ) resistor r=rsh / multi * l * factor / (w * factor - dw) * (1 + pvc1
+ * (abs(v(n2,n1)) / l / factor) + pvc2 * (v(n2,n1) / l / factor) * (v(n2,n1) /
+ l / factor)) * tfac
ends rm5s

// **********************************     Metal 5 with W/S=0.135/0.045     ***********************************
subckt rm5w ( n1 n2 )
parameters l=1u w=1u factor=factor_res_metal multi=1 rsh=r_rm5w dw=0 pvc1=0
+ pvc2=0 ptc1=2.04e-03 ptc2=-2.50e-07 pt=temp tfac=1.0 + ptc1 * (pt - 25.0) +
+ ptc2 * (pt - 25.0) * (pt - 25.0)
r1 ( n1 n2 ) resistor r=rsh / multi * l * factor / (w * factor - dw) * (1 + pvc1
+ * (abs(v(n2,n1)) / l / factor) + pvc2 * (v(n2,n1) / l / factor) * (v(n2,n1) /
+ l / factor)) * tfac
ends rm5w

// **********************************     Metal 6 with W/S=0.045/0.135     ***********************************
subckt rm6l ( n1 n2 )
parameters l=1u w=1u factor=factor_res_metal multi=1 rsh=r_rm6l dw=0 pvc1=0
+ pvc2=0 ptc1=2.02e-03 ptc2=-2.80e-07 pt=temp tfac=1.0 + ptc1 * (pt - 25.0) +
+ ptc2 * (pt - 25.0) * (pt - 25.0)
r1 ( n1 n2 ) resistor r=rsh / multi * l * factor / (w * factor - dw) * (1 + pvc1
+ * (abs(v(n2,n1)) / l / factor) + pvc2 * (v(n2,n1) / l / factor) * (v(n2,n1) /
+ l / factor)) * tfac
ends rm6l

// **********************************     Metal 6 with W/S=0.045/0.045     ***********************************
subckt rm6s ( n1 n2 )
parameters l=1u w=1u factor=factor_res_metal multi=1 rsh=r_rm6s dw=0 pvc1=0
+ pvc2=0 ptc1=1.94e-03 ptc2=-4.64e-07 pt=temp tfac=1.0 + ptc1 * (pt - 25.0) +
+ ptc2 * (pt - 25.0) * (pt - 25.0)
r1 ( n1 n2 ) resistor r=rsh / multi * l * factor / (w * factor - dw) * (1 + pvc1
+ * (abs(v(n2,n1)) / l / factor) + pvc2 * (v(n2,n1) / l / factor) * (v(n2,n1) /
+ l / factor)) * tfac
ends rm6s

// **********************************     Metal 6 with W/S=0.135/0.045     ***********************************
subckt rm6w ( n1 n2 )
parameters l=1u w=1u factor=factor_res_metal multi=1 rsh=r_rm6w dw=0 pvc1=0
+ pvc2=0 ptc1=2.04e-03 ptc2=-2.50e-07 pt=temp tfac=1.0 + ptc1 * (pt - 25.0) +
+ ptc2 * (pt - 25.0) * (pt - 25.0)
r1 ( n1 n2 ) resistor r=rsh / multi * l * factor / (w * factor - dw) * (1 + pvc1
+ * (abs(v(n2,n1)) / l / factor) + pvc2 * (v(n2,n1) / l / factor) * (v(n2,n1) /
+ l / factor)) * tfac
ends rm6w

// **********************************     Metal 7 with W/S=0.045/0.135     ***********************************
subckt rm7l ( n1 n2 )
parameters l=1u w=1u factor=factor_res_metal multi=1 rsh=r_rm7l dw=0 pvc1=0
+ pvc2=0 ptc1=2.02e-03 ptc2=-2.80e-07 pt=temp tfac=1.0 + ptc1 * (pt - 25.0) +
+ ptc2 * (pt - 25.0) * (pt - 25.0)
r1 ( n1 n2 ) resistor r=rsh / multi * l * factor / (w * factor - dw) * (1 + pvc1
+ * (abs(v(n2,n1)) / l / factor) + pvc2 * (v(n2,n1) / l / factor) * (v(n2,n1) /
+ l / factor)) * tfac
ends rm7l

// **********************************     Metal 7 with W/S=0.045/0.045     ***********************************
subckt rm7s ( n1 n2 )
parameters l=1u w=1u factor=factor_res_metal multi=1 rsh=r_rm7s dw=0 pvc1=0
+ pvc2=0 ptc1=1.94e-03 ptc2=-4.64e-07 pt=temp tfac=1.0 + ptc1 * (pt - 25.0) +
+ ptc2 * (pt - 25.0) * (pt - 25.0)
r1 ( n1 n2 ) resistor r=rsh / multi * l * factor / (w * factor - dw) * (1 + pvc1
+ * (abs(v(n2,n1)) / l / factor) + pvc2 * (v(n2,n1) / l / factor) * (v(n2,n1) /
+ l / factor)) * tfac
ends rm7s

// **********************************     Metal 7 with W/S=0.135/0.045     ***********************************
subckt rm7w ( n1 n2 )
parameters l=1u w=1u factor=factor_res_metal multi=1 rsh=r_rm7w dw=0 pvc1=0
+ pvc2=0 ptc1=2.04e-03 ptc2=-2.50e-07 pt=temp tfac=1.0 + ptc1 * (pt - 25.0) +
+ ptc2 * (pt - 25.0) * (pt - 25.0)
r1 ( n1 n2 ) resistor r=rsh / multi * l * factor / (w * factor - dw) * (1 + pvc1
+ * (abs(v(n2,n1)) / l / factor) + pvc2 * (v(n2,n1) / l / factor) * (v(n2,n1) /
+ l / factor)) * tfac
ends rm7w

// **********************************     Metal 8 with W/S=0.045/0.135     ***********************************
subckt rm8l ( n1 n2 )
parameters l=1u w=1u factor=factor_res_metal multi=1 rsh=r_rm8l dw=0 pvc1=0
+ pvc2=0 ptc1=2.02e-03 ptc2=-2.80e-07 pt=temp tfac=1.0 + ptc1 * (pt - 25.0) +
+ ptc2 * (pt - 25.0) * (pt - 25.0)
r1 ( n1 n2 ) resistor r=rsh / multi * l * factor / (w * factor - dw) * (1 + pvc1
+ * (abs(v(n2,n1)) / l / factor) + pvc2 * (v(n2,n1) / l / factor) * (v(n2,n1) /
+ l / factor)) * tfac
ends rm8l

// **********************************     Metal 8 with W/S=0.045/0.045     ***********************************
subckt rm8s ( n1 n2 )
parameters l=1u w=1u factor=factor_res_metal multi=1 rsh=r_rm8s dw=0 pvc1=0
+ pvc2=0 ptc1=1.94e-03 ptc2=-4.64e-07 pt=temp tfac=1.0 + ptc1 * (pt - 25.0) +
+ ptc2 * (pt - 25.0) * (pt - 25.0)
r1 ( n1 n2 ) resistor r=rsh / multi * l * factor / (w * factor - dw) * (1 + pvc1
+ * (abs(v(n2,n1)) / l / factor) + pvc2 * (v(n2,n1) / l / factor) * (v(n2,n1) /
+ l / factor)) * tfac
ends rm8s

// **********************************     Metal 8 with W/S=0.135/0.045     ***********************************
subckt rm8w ( n1 n2 )
parameters l=1u w=1u factor=factor_res_metal multi=1 rsh=r_rm8w dw=0 pvc1=0
+ pvc2=0 ptc1=2.04e-03 ptc2=-2.50e-07 pt=temp tfac=1.0 + ptc1 * (pt - 25.0) +
+ ptc2 * (pt - 25.0) * (pt - 25.0)
r1 ( n1 n2 ) resistor r=rsh / multi * l * factor / (w * factor - dw) * (1 + pvc1
+ * (abs(v(n2,n1)) / l / factor) + pvc2 * (v(n2,n1) / l / factor) * (v(n2,n1) /
+ l / factor)) * tfac
ends rm8w

// **********************************     Metal 9 with W/S=0.36/1.08     ***********************************
subckt rm9l ( n1 n2 )
parameters l=1u w=1u factor=factor_res_metal multi=1 rsh=r_rm9l dw=0 pvc1=0
+ pvc2=0 ptc1=3.65e-03 ptc2=-8.53e-07 pt=temp tfac=1.0 + ptc1 * (pt - 25.0) +
+ ptc2 * (pt - 25.0) * (pt - 25.0)
r1 ( n1 n2 ) resistor r=rsh / multi * l * factor / (w * factor - dw) * (1 + pvc1
+ * (abs(v(n2,n1)) / l / factor) + pvc2 * (v(n2,n1) / l / factor) * (v(n2,n1) /
+ l / factor)) * tfac
ends rm9l

// **********************************     Metal 9 with W/S=0.36/0.36     ***********************************
subckt rm9s ( n1 n2 )
parameters l=1u w=1u factor=factor_res_metal multi=1 rsh=r_rm9s dw=0 pvc1=0
+ pvc2=0 ptc1=3.65e-03 ptc2=-8.53e-07 pt=temp tfac=1.0 + ptc1 * (pt - 25.0) +
+ ptc2 * (pt - 25.0) * (pt - 25.0)
r1 ( n1 n2 ) resistor r=rsh / multi * l * factor / (w * factor - dw) * (1 + pvc1
+ * (abs(v(n2,n1)) / l / factor) + pvc2 * (v(n2,n1) / l / factor) * (v(n2,n1) /
+ l / factor)) * tfac
ends rm9s

// **********************************     Metal 9 with W/S=1.08/0.36     ***********************************
subckt rm9w ( n1 n2 )
parameters l=1u w=1u factor=factor_res_metal multi=1 rsh=r_rm9w dw=0 pvc1=0
+ pvc2=0 ptc1=3.78e-03 ptc2=-9.44e-07 pt=temp tfac=1.0 + ptc1 * (pt - 25.0) +
+ ptc2 * (pt - 25.0) * (pt - 25.0)
r1 ( n1 n2 ) resistor r=rsh / multi * l * factor / (w * factor - dw) * (1 + pvc1
+ * (abs(v(n2,n1)) / l / factor) + pvc2 * (v(n2,n1) / l / factor) * (v(n2,n1) /
+ l / factor)) * tfac
ends rm9w

// **********************************     Metal 10 with W/S=0.36/1.08     ***********************************
subckt rm10l ( n1 n2 )
parameters l=1u w=1u factor=factor_res_metal multi=1 rsh=r_rm10l dw=0 pvc1=0
+ pvc2=0 ptc1=3.65e-03 ptc2=-8.53e-07 pt=temp tfac=1.0 + ptc1 * (pt - 25.0) +
+ ptc2 * (pt - 25.0) * (pt - 25.0)
r1 ( n1 n2 ) resistor r=rsh / multi * l * factor / (w * factor - dw) * (1 + pvc1
+ * (abs(v(n2,n1)) / l / factor) + pvc2 * (v(n2,n1) / l / factor) * (v(n2,n1) /
+ l / factor)) * tfac
ends rm10l

// **********************************     Metal 10 with W/S=0.36/0.36     ***********************************
subckt rm10s ( n1 n2 )
parameters l=1u w=1u factor=factor_res_metal multi=1 rsh=r_rm10s dw=0 pvc1=0
+ pvc2=0 ptc1=3.65e-03 ptc2=-8.53e-07 pt=temp tfac=1.0 + ptc1 * (pt - 25.0) +
+ ptc2 * (pt - 25.0) * (pt - 25.0)
r1 ( n1 n2 ) resistor r=rsh / multi * l * factor / (w * factor - dw) * (1 + pvc1
+ * (abs(v(n2,n1)) / l / factor) + pvc2 * (v(n2,n1) / l / factor) * (v(n2,n1) /
+ l / factor)) * tfac
ends rm10s

// **********************************     Metal 10 with W/S=1.08/0.36     ***********************************
subckt rm10w ( n1 n2 )
parameters l=1u w=1u factor=factor_res_metal multi=1 rsh=r_rm10w dw=0 pvc1=0
+ pvc2=0 ptc1=3.78e-03 ptc2=-9.44e-07 pt=temp tfac=1.0 + ptc1 * (pt - 25.0) +
+ ptc2 * (pt - 25.0) * (pt - 25.0)
r1 ( n1 n2 ) resistor r=rsh / multi * l * factor / (w * factor - dw) * (1 + pvc1
+ * (abs(v(n2,n1)) / l / factor) + pvc2 * (v(n2,n1) / l / factor) * (v(n2,n1) /
+ l / factor)) * tfac
ends rm10w

// **********************************     AL_RDL with W/S=1.8/1.8     ***********************************
subckt rmap ( n1 n2 )
parameters l=1u w=1u factor=factor_res_metal multi=1 rsh=r_rmap dw=0 pvc1=0
+ pvc2=0 ptc1=3.89e-03 ptc2=-1.50e-07 pt=temp tfac=1.0 + ptc1 * (pt - 25.0) +
+ ptc2 * (pt - 25.0) * (pt - 25.0)
r1 ( n1 n2 ) resistor r=rsh / multi * l * factor / (w * factor - dw) * (1 + pvc1
+ * (abs(v(n2,n1)) / l / factor) + pvc2 * (v(n2,n1) / l / factor) * (v(n2,n1) /
+ l / factor)) * tfac
ends rmap

// **********************************     Metal x with W/S=0.045/0.135     ***********************************
subckt rmxl ( n1 n2 )
parameters l=1u w=1u factor=factor_res_metal multi=1 rsh=r_rmxl dw=0 pvc1=0
+ pvc2=0 ptc1=2.02e-03 ptc2=-2.80e-07 pt=temp tfac=1.0 + ptc1 * (pt - 25.0) +
+ ptc2 * (pt - 25.0) * (pt - 25.0)
r1 ( n1 n2 ) resistor r=rsh / multi * l * factor / (w * factor - dw) * (1 + pvc1
+ * (abs(v(n2,n1)) / l / factor) + pvc2 * (v(n2,n1) / l / factor) * (v(n2,n1) /
+ l / factor)) * tfac
ends rmxl

// **********************************     Metal x with W/S=0.045/0.045     ***********************************
subckt rmxs ( n1 n2 )
parameters l=1u w=1u factor=factor_res_metal multi=1 rsh=r_rmxs dw=0 pvc1=0
+ pvc2=0 ptc1=1.94e-03 ptc2=-4.64e-07 pt=temp tfac=1.0 + ptc1 * (pt - 25.0) +
+ ptc2 * (pt - 25.0) * (pt - 25.0)
r1 ( n1 n2 ) resistor r=rsh / multi * l * factor / (w * factor - dw) * (1 + pvc1
+ * (abs(v(n2,n1)) / l / factor) + pvc2 * (v(n2,n1) / l / factor) * (v(n2,n1) /
+ l / factor)) * tfac
ends rmxs

// **********************************     Metal x with W/S=0.135/0.045     ***********************************
subckt rmxw ( n1 n2 )
parameters l=1u w=1u factor=factor_res_metal multi=1 rsh=r_rmxw dw=0 pvc1=0
+ pvc2=0 ptc1=2.04e-03 ptc2=-2.50e-07 pt=temp tfac=1.0 + ptc1 * (pt - 25.0) +
+ ptc2 * (pt - 25.0) * (pt - 25.0)
r1 ( n1 n2 ) resistor r=rsh / multi * l * factor / (w * factor - dw) * (1 + pvc1
+ * (abs(v(n2,n1)) / l / factor) + pvc2 * (v(n2,n1) / l / factor) * (v(n2,n1) /
+ l / factor)) * tfac
ends rmxw

// **********************************     Metal z with W/S=0.36/1.08     ***********************************
subckt rmzl ( n1 n2 )
parameters l=1u w=1u factor=factor_res_metal multi=1 rsh=r_rmzl dw=0 pvc1=0
+ pvc2=0 ptc1=3.65e-03 ptc2=-8.53e-07 pt=temp tfac=1.0 + ptc1 * (pt - 25.0) +
+ ptc2 * (pt - 25.0) * (pt - 25.0)
r1 ( n1 n2 ) resistor r=rsh / multi * l * factor / (w * factor - dw) * (1 + pvc1
+ * (abs(v(n2,n1)) / l / factor) + pvc2 * (v(n2,n1) / l / factor) * (v(n2,n1) /
+ l / factor)) * tfac
ends rmzl

// **********************************     Metal z with W/S=0.36/0.36     ***********************************
subckt rmzs ( n1 n2 )
parameters l=1u w=1u factor=factor_res_metal multi=1 rsh=r_rmzs dw=0 pvc1=0
+ pvc2=0 ptc1=3.65e-03 ptc2=-8.53e-07 pt=temp tfac=1.0 + ptc1 * (pt - 25.0) +
+ ptc2 * (pt - 25.0) * (pt - 25.0)
r1 ( n1 n2 ) resistor r=rsh / multi * l * factor / (w * factor - dw) * (1 + pvc1
+ * (abs(v(n2,n1)) / l / factor) + pvc2 * (v(n2,n1) / l / factor) * (v(n2,n1) /
+ l / factor)) * tfac
ends rmzs

// **********************************     Metal z with W/S=1.08/0.36     ***********************************
subckt rmzw ( n1 n2 )
parameters l=1u w=1u factor=factor_res_metal multi=1 rsh=r_rmzw dw=0 pvc1=0
+ pvc2=0 ptc1=3.78e-03 ptc2=-9.44e-07 pt=temp tfac=1.0 + ptc1 * (pt - 25.0) +
+ ptc2 * (pt - 25.0) * (pt - 25.0)
r1 ( n1 n2 ) resistor r=rsh / multi * l * factor / (w * factor - dw) * (1 + pvc1
+ * (abs(v(n2,n1)) / l / factor) + pvc2 * (v(n2,n1) / l / factor) * (v(n2,n1) /
+ l / factor)) * tfac
ends rmzw

endsection res_metal
endlibrary tsmclib
