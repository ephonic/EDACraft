//
//*  **************************************************************
//*  *  TSMC SPICE MODEL --- Security B - TSMC Restricted Secret  *
//*  **************************************************************
//*
//*    PROCESS :  0.028um Mixed Signal RF LC Tank HIGH PERFORMANCE COMPACT MOBILE COMPUTING PLUS (0.9V/2.5V)(CRN28HT LCT)
//*    MODEL   :  BSIM4 ( V4.5 )
//*    DOC. NO.:  T-N28-CR-SP-023
//*    VERSION :  v1.0_2p1
//*    DATE    :  02:00PM, Feb. 02, 2016
//*    SPECTRE VERSION : 14.1.0.804.isr12
//*
//***********************************************************************************
//       THIS INCLUDE HEADER CONTAINS :                                             *
//                                                                                  *
//    Total Corner :                                                                *
//	top_tt   totalflag_xx=1 globalflag_xx=1 mismatchflag_xx=1              	    *
//                                                                                  *
//***********************************************************************************

simulator lang=spectre insensitive=yes
library tsmclib

section top_tt
include "./crn28hpcp_lct_2d5_elk_v1d0_2p1_shrink0d9_embedded_usage.scs" section=ttmacro_mos_moscap
include "./crn28hpcp_lct_2d5_elk_v1d0_2p1_shrink0d9_embedded_usage.scs" section=tt_res_bip_dio_disres
include "./crn28hpcp_lct_2d5_elk_v1d0_2p1_shrink0d9_embedded_usage.scs" section=tt_mom
include "./crn28hpcp_lct_2d5_elk_v1d0_2p1_shrink0d9_embedded_usage.scs" section=tt_r_metal
endsection top_tt
