//**************************************************************
//*  tsmc spice model --- security b - tsmc restricted secret  *
//**************************************************************
section pre_simu
setscale options scalefactor=0.9
parOpt options redefinedparams=ignore
parameters ccoflag_hv18=1
parameters rgflag_hv18=1
parameters rcoflag_hv18=1
endsection pre_simu

section ttmacro_mos_moscap
setscale options scalefactor=0.9
include "cln28hpcp_hv_1d8_elk_v0d1_2p1.scs" section=tt_hv18
include "cln28hpcp_hv_1d8_elk_v0d1_2p1.scs" section=global_hv18
include "cln28hpcp_hv_1d8_elk_v0d1_2p1.scs" section=total_hv18
include "cln28hpcp_hv_1d8_elk_v0d1_2p1.scs" section=stat_hv
endsection ttmacro_mos_moscap

section ssmacro_mos_moscap
setscale options scalefactor=0.9
include "cln28hpcp_hv_1d8_elk_v0d1_2p1.scs" section=ss_hv18
include "cln28hpcp_hv_1d8_elk_v0d1_2p1.scs" section=global_hv18
include "cln28hpcp_hv_1d8_elk_v0d1_2p1.scs" section=total_hv18
include "cln28hpcp_hv_1d8_elk_v0d1_2p1.scs" section=stat_hv
endsection ssmacro_mos_moscap

section ffmacro_mos_moscap
setscale options scalefactor=0.9
include "cln28hpcp_hv_1d8_elk_v0d1_2p1.scs" section=ff_hv18
include "cln28hpcp_hv_1d8_elk_v0d1_2p1.scs" section=global_hv18
include "cln28hpcp_hv_1d8_elk_v0d1_2p1.scs" section=total_hv18
include "cln28hpcp_hv_1d8_elk_v0d1_2p1.scs" section=stat_hv
endsection ffmacro_mos_moscap

section sfmacro_mos_moscap
setscale options scalefactor=0.9
include "cln28hpcp_hv_1d8_elk_v0d1_2p1.scs" section=sf_hv18
include "cln28hpcp_hv_1d8_elk_v0d1_2p1.scs" section=global_hv18
include "cln28hpcp_hv_1d8_elk_v0d1_2p1.scs" section=total_hv18
include "cln28hpcp_hv_1d8_elk_v0d1_2p1.scs" section=stat_hv
endsection sfmacro_mos_moscap

section fsmacro_mos_moscap
setscale options scalefactor=0.9
include "cln28hpcp_hv_1d8_elk_v0d1_2p1.scs" section=fs_hv18
include "cln28hpcp_hv_1d8_elk_v0d1_2p1.scs" section=global_hv18
include "cln28hpcp_hv_1d8_elk_v0d1_2p1.scs" section=total_hv18
include "cln28hpcp_hv_1d8_elk_v0d1_2p1.scs" section=stat_hv
endsection fsmacro_mos_moscap

section ttglobalcorner_localmc_mos_moscap
setscale options scalefactor=0.9
include "cln28hpcp_hv_1d8_elk_v0d1_2p1.scs" section=ttg_hv18
include "cln28hpcp_hv_1d8_elk_v0d1_2p1.scs" section=tt_hv18
include "cln28hpcp_hv_1d8_elk_v0d1_2p1.scs" section=total_hv18
include "cln28hpcp_hv_1d8_elk_v0d1_2p1.scs" section=stat_hv
parOpt options redefinedparams=ignore
parameters totalflag_mos_hv18=0
endsection ttglobalcorner_localmc_mos_moscap

section ssglobalcorner_localmc_mos_moscap
setscale options scalefactor=0.9
include "cln28hpcp_hv_1d8_elk_v0d1_2p1.scs" section=ssg_hv18
include "cln28hpcp_hv_1d8_elk_v0d1_2p1.scs" section=tt_hv18
include "cln28hpcp_hv_1d8_elk_v0d1_2p1.scs" section=total_hv18
include "cln28hpcp_hv_1d8_elk_v0d1_2p1.scs" section=stat_hv
parOpt options redefinedparams=ignore
parameters totalflag_mos_hv18=0
endsection ssglobalcorner_localmc_mos_moscap

section ffglobalcorner_localmc_mos_moscap
setscale options scalefactor=0.9
include "cln28hpcp_hv_1d8_elk_v0d1_2p1.scs" section=ffg_hv18
include "cln28hpcp_hv_1d8_elk_v0d1_2p1.scs" section=tt_hv18
include "cln28hpcp_hv_1d8_elk_v0d1_2p1.scs" section=total_hv18
include "cln28hpcp_hv_1d8_elk_v0d1_2p1.scs" section=stat_hv
parOpt options redefinedparams=ignore
parameters totalflag_mos_hv18=0
endsection ffglobalcorner_localmc_mos_moscap

section sfglobalcorner_localmc_mos_moscap
setscale options scalefactor=0.9
include "cln28hpcp_hv_1d8_elk_v0d1_2p1.scs" section=sfg_hv18
include "cln28hpcp_hv_1d8_elk_v0d1_2p1.scs" section=tt_hv18
include "cln28hpcp_hv_1d8_elk_v0d1_2p1.scs" section=total_hv18
include "cln28hpcp_hv_1d8_elk_v0d1_2p1.scs" section=stat_hv
parOpt options redefinedparams=ignore
parameters totalflag_mos_hv18=0
endsection sfglobalcorner_localmc_mos_moscap

section fsglobalcorner_localmc_mos_moscap
setscale options scalefactor=0.9
include "cln28hpcp_hv_1d8_elk_v0d1_2p1.scs" section=fsg_hv18
include "cln28hpcp_hv_1d8_elk_v0d1_2p1.scs" section=tt_hv18
include "cln28hpcp_hv_1d8_elk_v0d1_2p1.scs" section=total_hv18
include "cln28hpcp_hv_1d8_elk_v0d1_2p1.scs" section=stat_hv
parOpt options redefinedparams=ignore
parameters totalflag_mos_hv18=0
endsection fsglobalcorner_localmc_mos_moscap

section localmconly_mos_moscap
setscale options scalefactor=0.9
include "cln28hpcp_hv_1d8_elk_v0d1_2p1.scs" section=tt_hv18
include "cln28hpcp_hv_1d8_elk_v0d1_2p1.scs" section=global_hv18
include "cln28hpcp_hv_1d8_elk_v0d1_2p1.scs" section=total_hv18
include "cln28hpcp_hv_1d8_elk_v0d1_2p1.scs" section=stat_hv
parOpt options redefinedparams=ignore
parameters totalflag_mos_hv18=0
parameters globalflag_mos_hv18=0
endsection localmconly_mos_moscap

section globalmc_localmc_mos_moscap
setscale options scalefactor=0.9
include "cln28hpcp_hv_1d8_elk_v0d1_2p1.scs" section=tt_hv18
include "cln28hpcp_hv_1d8_elk_v0d1_2p1.scs" section=global_hv18
include "cln28hpcp_hv_1d8_elk_v0d1_2p1.scs" section=total_hv18
include "cln28hpcp_hv_1d8_elk_v0d1_2p1.scs" section=stat_hv
parOpt options redefinedparams=ignore
parameters totalflag_mos_hv18=0
endsection globalmc_localmc_mos_moscap
