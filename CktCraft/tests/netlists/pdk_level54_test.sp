* C1 level=54 routing test: HSPICE-native BSIM4 model card → bsim4.dll (OSDI)
* 验证 .model nmos (level=54 ...) 路由到 bsim4.dll，参数正确传递。
VDD vdd 0 1.2
RD  vdd d  10k
VG  g   0  0.7
M1 d g 0 0 nch w=1u l=130n
.model nch nmos (
+ level    = 54
+ version  = 4.5
+ tnom     = 27
+ toxe     = 3e-9
+ toxm     = 3e-9
+ dtox     = 0
+ epsrox   = 3.9
+ toxref   = 3e-9
+ wint     = 0
+ lint     = 0
+ xj       = 7e-8
+ ngate    = 1e21
+ ndep     = 2.07e17
+ nsd      = 1e20
+ vth0     = 0.4
+ k1       = 0.3
+ k2       = 0.003
+ k3       = -5.98
+ k3b      = 3.24
+ dvt0     = 9.2
+ dvt1     = 0.17
+ dvt2     = -0.019
+ dsub     = 0.33
+ minv     = -0.069
+ voff     = -0.13
+ nfactor  = 0.5
+ eta0     = 0.076
+ etab     = -0.035
+ u0       = 0.021
+ ua       = -1.8e-9
+ ub       = 2.2e-18
+ uc       = 1.27e-10
+ vsat     = 491929
+ a0       = 1.0
+ ags      = 0.1
+ a1       = 0
+ a2       = 1
+ b0       = 0
+ b1       = 0
+ mobmod   = 0
+ capmod   = 2
+ igcmod   = 0
+ igbmod   = 0
+ geomod   = 0
+ diomod   = 1
+ rdsmod   = 1
+ rbodymod = 0
+ rgeomod  = 1
+ rgatemod = 0
+ permod   = 1
+ acnqsmod = 0
+ trnqsmod = 0
+ tempmod  = 1
+ wpemod   = 0
+ paramchk = 1
+ binunit  = 2
+ xl       = 1e-8
+ xw       = 1.5e-8
+ dlc      = 0
+ dwc      = 0
+ cdsc     = 2e-7
+ cdscb    = -2.8e-7
+ cdscd    = 2.2e-7
+ cit      = -0.001
+ lmin     = 5.4e-7
+ lmax     = 1.08e-6
+ wmin     = 1.8e-6
+ wmax     = 4.5e-6
+ ll       = 0
+ wl       = 0
+ lwn      = 1
+ wwn      = 1
+ lln      = 1
+ wln      = 1
)
.op
.print v(d) i(vdd)
.end
