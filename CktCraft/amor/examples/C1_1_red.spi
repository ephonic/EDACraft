*.reduced circuit
*subckt: 0
RPR_0_0 in1 3149 22.8571
RPR_0_1 in1 3151 22.8571
RPR_0_2 in1 3150 79.2858
RPR_0_3 in1 3152 79.2858
RPR_0_4 in1 3172 36.5131
RPR_0_5 3153 3172 27.1429
RPR_0_6 3155 3172 67.9465
RPR_0_7 3155 3148 178.437
RPR_0_8 3148 3172 67.9465
RPR_0_9 3150 3152 172.164
RPR_0_10 3150 3172 79.2858
RPR_0_11 3152 3172 79.2858
RPR_0_12 3154 3172 27.1429
CPR_0_13 in1 GND 2.77472e-016
CPR_0_14 3155 GND 1.09744e-016
CPR_0_15 3148 GND 1.08194e-016
CPR_0_16 3172 GND 2.90295e-016
*subckt: 1
*subckt: 2
RPR_2_0 o69 4966 186.751
RPR_2_1 o69 4967 186.751
RPR_2_2 o69 4968 186.751
RPR_2_3 o69 4969 130.726
RPR_2_4 o69 4970 130.726
RPR_2_5 o69 4971 130.726
CPR_2_6 o69 GND 1.85013e-015
*subckt: 3
RPR_3_0 o68 4938 186.751
RPR_3_1 o68 4939 186.751
RPR_3_2 o68 4940 186.751
RPR_3_3 o68 4941 130.726
RPR_3_4 o68 4942 130.726
RPR_3_5 o68 4943 130.726
CPR_3_6 o68 GND 1.85013e-015
*subckt: 4
RPR_4_0 o67 4910 186.751
RPR_4_1 o67 4911 186.751
RPR_4_2 o67 4912 186.751
RPR_4_3 o67 4913 130.726
RPR_4_4 o67 4914 130.726
RPR_4_5 o67 4915 130.726
CPR_4_6 o67 GND 1.85013e-015
*subckt: 5
RPR_5_0 o66 4882 186.751
RPR_5_1 o66 4883 186.751
RPR_5_2 o66 4884 186.751
RPR_5_3 o66 4885 130.726
RPR_5_4 o66 4886 130.726
RPR_5_5 o66 4887 130.726
CPR_5_6 o66 GND 1.85013e-015
*subckt: 6
RPR_6_0 o65 4854 186.751
RPR_6_1 o65 4855 186.751
RPR_6_2 o65 4856 186.751
RPR_6_3 o65 4857 130.726
RPR_6_4 o65 4858 130.726
RPR_6_5 o65 4859 130.726
CPR_6_6 o65 GND 1.85014e-015
*subckt: 7
RPR_7_0 o1 3023 186.751
RPR_7_1 o1 3024 186.751
RPR_7_2 o1 3025 186.751
RPR_7_3 o1 3026 130.726
RPR_7_4 o1 3027 130.726
RPR_7_5 o1 3028 130.726
CPR_7_6 o1 GND 1.85014e-015
*subckt: 8
RPR_8_0 o2 3051 186.751
RPR_8_1 o2 3052 186.751
RPR_8_2 o2 3053 186.751
RPR_8_3 o2 3054 130.726
RPR_8_4 o2 3055 130.726
RPR_8_5 o2 3056 130.726
CPR_8_6 o2 GND 1.85013e-015
*subckt: 9
RPR_9_0 o3 3079 186.751
RPR_9_1 o3 3080 186.751
RPR_9_2 o3 3081 186.751
RPR_9_3 o3 3082 130.726
RPR_9_4 o3 3083 130.726
RPR_9_5 o3 3084 130.726
CPR_9_6 o3 GND 1.85013e-015
*subckt: 10
RPR_10_0 o4 3107 186.751
RPR_10_1 o4 3108 186.751
RPR_10_2 o4 3109 186.751
RPR_10_3 o4 3110 130.726
RPR_10_4 o4 3111 130.726
RPR_10_5 o4 3112 130.726
CPR_10_6 o4 GND 1.85013e-015
*subckt: 11
RPR_11_0 o5 3135 186.751
RPR_11_1 o5 3136 186.751
RPR_11_2 o5 3137 186.751
RPR_11_3 o5 3138 130.726
RPR_11_4 o5 3139 130.726
RPR_11_5 o5 3140 130.726
CPR_11_6 o5 GND 1.85013e-015
*subckt: 12
RPR_12_0 o6 3195 186.751
RPR_12_1 o6 3196 186.751
RPR_12_2 o6 3197 186.751
RPR_12_3 o6 3198 130.726
RPR_12_4 o6 3199 130.726
RPR_12_5 o6 3200 130.726
CPR_12_6 o6 GND 1.85014e-015
*subckt: 13
RPR_13_0 o7 3223 186.751
RPR_13_1 o7 3224 186.751
RPR_13_2 o7 3225 186.751
RPR_13_3 o7 3226 130.726
RPR_13_4 o7 3227 130.726
RPR_13_5 o7 3228 130.726
CPR_13_6 o7 GND 1.85013e-015
*subckt: 14
RPR_14_0 o8 3251 186.751
RPR_14_1 o8 3252 186.751
RPR_14_2 o8 3253 186.751
RPR_14_3 o8 3254 130.726
RPR_14_4 o8 3255 130.726
RPR_14_5 o8 3256 130.726
CPR_14_6 o8 GND 1.85013e-015
*subckt: 15
RPR_15_0 o9 3279 186.751
RPR_15_1 o9 3280 186.751
RPR_15_2 o9 3281 186.751
RPR_15_3 o9 3282 130.726
RPR_15_4 o9 3283 130.726
RPR_15_5 o9 3284 130.726
CPR_15_6 o9 GND 1.85013e-015
*subckt: 16
RPR_16_0 o10 3307 186.751
RPR_16_1 o10 3308 186.751
RPR_16_2 o10 3309 186.751
RPR_16_3 o10 3310 130.726
RPR_16_4 o10 3311 130.726
RPR_16_5 o10 3312 130.726
CPR_16_6 o10 GND 1.85013e-015
*subckt: 17
RPR_17_0 o11 3335 186.751
RPR_17_1 o11 3336 186.751
RPR_17_2 o11 3337 186.751
RPR_17_3 o11 3338 130.726
RPR_17_4 o11 3339 130.726
RPR_17_5 o11 3340 130.726
CPR_17_6 o11 GND 1.85014e-015
*subckt: 18
RPR_18_0 o12 3363 186.751
RPR_18_1 o12 3364 186.751
RPR_18_2 o12 3365 186.751
RPR_18_3 o12 3366 130.726
RPR_18_4 o12 3367 130.726
RPR_18_5 o12 3368 130.726
CPR_18_6 o12 GND 1.85013e-015
*subckt: 19
RPR_19_0 o13 3391 186.751
RPR_19_1 o13 3392 186.751
RPR_19_2 o13 3393 186.751
RPR_19_3 o13 3394 130.726
RPR_19_4 o13 3395 130.726
RPR_19_5 o13 3396 130.726
CPR_19_6 o13 GND 1.85013e-015
*subckt: 20
RPR_20_0 o14 3419 186.751
RPR_20_1 o14 3420 186.751
RPR_20_2 o14 3421 186.751
RPR_20_3 o14 3422 130.726
RPR_20_4 o14 3423 130.726
RPR_20_5 o14 3424 130.726
CPR_20_6 o14 GND 1.85014e-015
*subckt: 21
RPR_21_0 o15 3447 186.751
RPR_21_1 o15 3448 186.751
RPR_21_2 o15 3449 186.751
RPR_21_3 o15 3450 130.726
RPR_21_4 o15 3451 130.726
RPR_21_5 o15 3452 130.726
CPR_21_6 o15 GND 1.85014e-015
*subckt: 22
RPR_22_0 o16 3475 186.751
RPR_22_1 o16 3476 186.751
RPR_22_2 o16 3477 186.751
RPR_22_3 o16 3478 130.726
RPR_22_4 o16 3479 130.726
RPR_22_5 o16 3480 130.726
CPR_22_6 o16 GND 1.85013e-015
*subckt: 23
RPR_23_0 o17 3505 186.751
RPR_23_1 o17 3506 186.751
RPR_23_2 o17 3507 186.751
RPR_23_3 o17 3508 130.726
RPR_23_4 o17 3509 130.726
RPR_23_5 o17 3510 130.726
CPR_23_6 o17 GND 1.85013e-015
*subckt: 24
RPR_24_0 o18 3533 186.751
RPR_24_1 o18 3534 186.751
RPR_24_2 o18 3535 186.751
RPR_24_3 o18 3536 130.726
RPR_24_4 o18 3537 130.726
RPR_24_5 o18 3538 130.726
CPR_24_6 o18 GND 1.85014e-015
*subckt: 25
RPR_25_0 o19 3561 186.751
RPR_25_1 o19 3562 186.751
RPR_25_2 o19 3563 186.751
RPR_25_3 o19 3564 130.726
RPR_25_4 o19 3565 130.726
RPR_25_5 o19 3566 130.726
CPR_25_6 o19 GND 1.85014e-015
*subckt: 26
RPR_26_0 o20 3589 186.751
RPR_26_1 o20 3590 186.751
RPR_26_2 o20 3591 186.751
RPR_26_3 o20 3592 130.726
RPR_26_4 o20 3593 130.726
RPR_26_5 o20 3594 130.726
CPR_26_6 o20 GND 1.85014e-015
*subckt: 27
RPR_27_0 o21 3617 186.751
RPR_27_1 o21 3618 186.751
RPR_27_2 o21 3619 186.751
RPR_27_3 o21 3620 130.726
RPR_27_4 o21 3621 130.726
RPR_27_5 o21 3622 130.726
CPR_27_6 o21 GND 1.85014e-015
*subckt: 28
RPR_28_0 o22 3645 186.751
RPR_28_1 o22 3646 186.751
RPR_28_2 o22 3647 186.751
RPR_28_3 o22 3648 130.726
RPR_28_4 o22 3649 130.726
RPR_28_5 o22 3650 130.726
CPR_28_6 o22 GND 1.85013e-015
*subckt: 29
RPR_29_0 o23 3673 186.751
RPR_29_1 o23 3674 186.751
RPR_29_2 o23 3675 186.751
RPR_29_3 o23 3676 130.726
RPR_29_4 o23 3677 130.726
RPR_29_5 o23 3678 130.726
CPR_29_6 o23 GND 1.85014e-015
*subckt: 30
RPR_30_0 o24 3701 186.751
RPR_30_1 o24 3702 186.751
RPR_30_2 o24 3703 186.751
RPR_30_3 o24 3704 130.726
RPR_30_4 o24 3705 130.726
RPR_30_5 o24 3706 130.726
CPR_30_6 o24 GND 1.85014e-015
*subckt: 31
RPR_31_0 o25 3729 186.751
RPR_31_1 o25 3730 186.751
RPR_31_2 o25 3731 186.751
RPR_31_3 o25 3732 130.726
RPR_31_4 o25 3733 130.726
RPR_31_5 o25 3734 130.726
CPR_31_6 o25 GND 1.85014e-015
*subckt: 32
RPR_32_0 o26 3757 186.751
RPR_32_1 o26 3758 186.751
RPR_32_2 o26 3759 186.751
RPR_32_3 o26 3760 130.726
RPR_32_4 o26 3761 130.726
RPR_32_5 o26 3762 130.726
CPR_32_6 o26 GND 1.85014e-015
*subckt: 33
RPR_33_0 o27 3785 186.751
RPR_33_1 o27 3786 186.751
RPR_33_2 o27 3787 186.751
RPR_33_3 o27 3788 130.726
RPR_33_4 o27 3789 130.726
RPR_33_5 o27 3790 130.726
CPR_33_6 o27 GND 1.85013e-015
*subckt: 34
RPR_34_0 o28 3813 186.751
RPR_34_1 o28 3814 186.751
RPR_34_2 o28 3815 186.751
RPR_34_3 o28 3816 130.726
RPR_34_4 o28 3817 130.726
RPR_34_5 o28 3818 130.726
CPR_34_6 o28 GND 1.85014e-015
*subckt: 35
RPR_35_0 o29 3842 186.751
RPR_35_1 o29 3843 186.751
RPR_35_2 o29 3844 186.751
RPR_35_3 o29 3845 130.726
RPR_35_4 o29 3846 130.726
RPR_35_5 o29 3847 130.726
CPR_35_6 o29 GND 1.85014e-015
*subckt: 36
RPR_36_0 o30 3870 186.751
RPR_36_1 o30 3871 186.751
RPR_36_2 o30 3872 186.751
RPR_36_3 o30 3873 130.726
RPR_36_4 o30 3874 130.726
RPR_36_5 o30 3875 130.726
CPR_36_6 o30 GND 1.85013e-015
*subckt: 37
RPR_37_0 o31 3898 186.751
RPR_37_1 o31 3899 186.751
RPR_37_2 o31 3900 186.751
RPR_37_3 o31 3901 130.726
RPR_37_4 o31 3902 130.726
RPR_37_5 o31 3903 130.726
CPR_37_6 o31 GND 1.85013e-015
*subckt: 38
RPR_38_0 o32 3926 186.751
RPR_38_1 o32 3927 186.751
RPR_38_2 o32 3928 186.751
RPR_38_3 o32 3929 130.726
RPR_38_4 o32 3930 130.726
RPR_38_5 o32 3931 130.726
CPR_38_6 o32 GND 1.85014e-015
*subckt: 39
RPR_39_0 o33 3956 186.751
RPR_39_1 o33 3957 186.751
RPR_39_2 o33 3958 186.751
RPR_39_3 o33 3959 130.726
RPR_39_4 o33 3960 130.726
RPR_39_5 o33 3961 130.726
CPR_39_6 o33 GND 1.85014e-015
*subckt: 40
RPR_40_0 o34 3984 186.751
RPR_40_1 o34 3985 186.751
RPR_40_2 o34 3986 186.751
RPR_40_3 o34 3987 130.726
RPR_40_4 o34 3988 130.726
RPR_40_5 o34 3989 130.726
CPR_40_6 o34 GND 1.85014e-015
*subckt: 41
RPR_41_0 o35 4012 186.751
RPR_41_1 o35 4013 186.751
RPR_41_2 o35 4014 186.751
RPR_41_3 o35 4015 130.726
RPR_41_4 o35 4016 130.726
RPR_41_5 o35 4017 130.726
CPR_41_6 o35 GND 1.85014e-015
*subckt: 42
RPR_42_0 o36 4040 186.751
RPR_42_1 o36 4041 186.751
RPR_42_2 o36 4042 186.751
RPR_42_3 o36 4043 130.726
RPR_42_4 o36 4044 130.726
RPR_42_5 o36 4045 130.726
CPR_42_6 o36 GND 1.85013e-015
*subckt: 43
RPR_43_0 o37 4068 186.751
RPR_43_1 o37 4069 186.751
RPR_43_2 o37 4070 186.751
RPR_43_3 o37 4071 130.726
RPR_43_4 o37 4072 130.726
RPR_43_5 o37 4073 130.726
CPR_43_6 o37 GND 1.85014e-015
*subckt: 44
RPR_44_0 o38 4096 186.751
RPR_44_1 o38 4097 186.751
RPR_44_2 o38 4098 186.751
RPR_44_3 o38 4099 130.726
RPR_44_4 o38 4100 130.726
RPR_44_5 o38 4101 130.726
CPR_44_6 o38 GND 1.85013e-015
*subckt: 45
RPR_45_0 o39 4124 186.751
RPR_45_1 o39 4125 186.751
RPR_45_2 o39 4126 186.751
RPR_45_3 o39 4127 130.726
RPR_45_4 o39 4128 130.726
RPR_45_5 o39 4129 130.726
CPR_45_6 o39 GND 1.85013e-015
*subckt: 46
RPR_46_0 o40 4152 186.751
RPR_46_1 o40 4153 186.751
RPR_46_2 o40 4154 186.751
RPR_46_3 o40 4155 130.726
RPR_46_4 o40 4156 130.726
RPR_46_5 o40 4157 130.726
CPR_46_6 o40 GND 1.85014e-015
*subckt: 47
RPR_47_0 o41 4180 186.751
RPR_47_1 o41 4181 186.751
RPR_47_2 o41 4182 186.751
RPR_47_3 o41 4183 130.726
RPR_47_4 o41 4184 130.726
RPR_47_5 o41 4185 130.726
CPR_47_6 o41 GND 1.85014e-015
*subckt: 48
RPR_48_0 o42 4208 186.751
RPR_48_1 o42 4209 186.751
RPR_48_2 o42 4210 186.751
RPR_48_3 o42 4211 130.726
RPR_48_4 o42 4212 130.726
RPR_48_5 o42 4213 130.726
CPR_48_6 o42 GND 1.85013e-015
*subckt: 49
RPR_49_0 o43 4236 186.751
RPR_49_1 o43 4237 186.751
RPR_49_2 o43 4238 186.751
RPR_49_3 o43 4239 130.726
RPR_49_4 o43 4240 130.726
RPR_49_5 o43 4241 130.726
CPR_49_6 o43 GND 1.85014e-015
*subckt: 50
RPR_50_0 o44 4265 186.751
RPR_50_1 o44 4266 186.751
RPR_50_2 o44 4267 186.751
RPR_50_3 o44 4268 130.726
RPR_50_4 o44 4269 130.726
RPR_50_5 o44 4270 130.726
CPR_50_6 o44 GND 1.85014e-015
*subckt: 51
RPR_51_0 o45 4293 186.751
RPR_51_1 o45 4294 186.751
RPR_51_2 o45 4295 186.751
RPR_51_3 o45 4296 130.726
RPR_51_4 o45 4297 130.726
RPR_51_5 o45 4298 130.726
CPR_51_6 o45 GND 1.85014e-015
*subckt: 52
RPR_52_0 o46 4321 186.751
RPR_52_1 o46 4322 186.751
RPR_52_2 o46 4323 186.751
RPR_52_3 o46 4324 130.726
RPR_52_4 o46 4325 130.726
RPR_52_5 o46 4326 130.726
CPR_52_6 o46 GND 1.85014e-015
*subckt: 53
RPR_53_0 o47 4349 186.751
RPR_53_1 o47 4350 186.751
RPR_53_2 o47 4351 186.751
RPR_53_3 o47 4352 130.726
RPR_53_4 o47 4353 130.726
RPR_53_5 o47 4354 130.726
CPR_53_6 o47 GND 1.85013e-015
*subckt: 54
RPR_54_0 o48 4377 186.751
RPR_54_1 o48 4378 186.751
RPR_54_2 o48 4379 186.751
RPR_54_3 o48 4380 130.726
RPR_54_4 o48 4381 130.726
RPR_54_5 o48 4382 130.726
CPR_54_6 o48 GND 1.85014e-015
*subckt: 55
RPR_55_0 o49 4405 186.751
RPR_55_1 o49 4406 186.751
RPR_55_2 o49 4407 186.751
RPR_55_3 o49 4408 130.726
RPR_55_4 o49 4409 130.726
RPR_55_5 o49 4410 130.726
CPR_55_6 o49 GND 1.85014e-015
*subckt: 56
RPR_56_0 o50 4433 186.751
RPR_56_1 o50 4434 186.751
RPR_56_2 o50 4435 186.751
RPR_56_3 o50 4436 130.726
RPR_56_4 o50 4437 130.726
RPR_56_5 o50 4438 130.726
CPR_56_6 o50 GND 1.85014e-015
*subckt: 57
RPR_57_0 o51 4461 186.751
RPR_57_1 o51 4462 186.751
RPR_57_2 o51 4463 186.751
RPR_57_3 o51 4464 130.726
RPR_57_4 o51 4465 130.726
RPR_57_5 o51 4466 130.726
CPR_57_6 o51 GND 1.85014e-015
*subckt: 58
RPR_58_0 o52 4489 186.751
RPR_58_1 o52 4490 186.751
RPR_58_2 o52 4491 186.751
RPR_58_3 o52 4492 130.726
RPR_58_4 o52 4493 130.726
RPR_58_5 o52 4494 130.726
CPR_58_6 o52 GND 1.85013e-015
*subckt: 59
RPR_59_0 o53 4517 186.751
RPR_59_1 o53 4518 186.751
RPR_59_2 o53 4519 186.751
RPR_59_3 o53 4520 130.726
RPR_59_4 o53 4521 130.726
RPR_59_5 o53 4522 130.726
CPR_59_6 o53 GND 1.85014e-015
*subckt: 60
RPR_60_0 o54 4545 186.751
RPR_60_1 o54 4546 186.751
RPR_60_2 o54 4547 186.751
RPR_60_3 o54 4548 130.726
RPR_60_4 o54 4549 130.726
RPR_60_5 o54 4550 130.726
CPR_60_6 o54 GND 1.85014e-015
*subckt: 61
RPR_61_0 o55 4573 186.751
RPR_61_1 o55 4574 186.751
RPR_61_2 o55 4575 186.751
RPR_61_3 o55 4576 130.726
RPR_61_4 o55 4577 130.726
RPR_61_5 o55 4578 130.726
CPR_61_6 o55 GND 1.85013e-015
*subckt: 62
RPR_62_0 o56 4601 186.751
RPR_62_1 o56 4602 186.751
RPR_62_2 o56 4603 186.751
RPR_62_3 o56 4604 130.726
RPR_62_4 o56 4605 130.726
RPR_62_5 o56 4606 130.726
CPR_62_6 o56 GND 1.85013e-015
*subckt: 63
RPR_63_0 o57 4629 186.751
RPR_63_1 o57 4630 186.751
RPR_63_2 o57 4631 186.751
RPR_63_3 o57 4632 130.726
RPR_63_4 o57 4633 130.726
RPR_63_5 o57 4634 130.726
CPR_63_6 o57 GND 1.85013e-015
*subckt: 64
RPR_64_0 o58 4657 186.751
RPR_64_1 o58 4658 186.751
RPR_64_2 o58 4659 186.751
RPR_64_3 o58 4660 130.726
RPR_64_4 o58 4661 130.726
RPR_64_5 o58 4662 130.726
CPR_64_6 o58 GND 1.85013e-015
*subckt: 65
RPR_65_0 o59 4685 186.751
RPR_65_1 o59 4686 186.751
RPR_65_2 o59 4687 186.751
RPR_65_3 o59 4688 130.726
RPR_65_4 o59 4689 130.726
RPR_65_5 o59 4690 130.726
CPR_65_6 o59 GND 1.85013e-015
*subckt: 66
RPR_66_0 o60 4714 186.751
RPR_66_1 o60 4715 186.751
RPR_66_2 o60 4716 186.751
RPR_66_3 o60 4717 130.726
RPR_66_4 o60 4718 130.726
RPR_66_5 o60 4719 130.726
CPR_66_6 o60 GND 1.85014e-015
*subckt: 67
RPR_67_0 o61 4742 186.751
RPR_67_1 o61 4743 186.751
RPR_67_2 o61 4744 186.751
RPR_67_3 o61 4745 130.726
RPR_67_4 o61 4746 130.726
RPR_67_5 o61 4747 130.726
CPR_67_6 o61 GND 1.85013e-015
*subckt: 68
RPR_68_0 o62 4770 186.751
RPR_68_1 o62 4771 186.751
RPR_68_2 o62 4772 186.751
RPR_68_3 o62 4773 130.726
RPR_68_4 o62 4774 130.726
RPR_68_5 o62 4775 130.726
CPR_68_6 o62 GND 1.85013e-015
*subckt: 69
RPR_69_0 o63 4798 186.751
RPR_69_1 o63 4799 186.751
RPR_69_2 o63 4800 186.751
RPR_69_3 o63 4801 130.726
RPR_69_4 o63 4802 130.726
RPR_69_5 o63 4803 130.726
CPR_69_6 o63 GND 1.85013e-015
*subckt: 70
RPR_70_0 o64 4826 186.751
RPR_70_1 o64 4827 186.751
RPR_70_2 o64 4828 186.751
RPR_70_3 o64 4829 130.726
RPR_70_4 o64 4830 130.726
RPR_70_5 o64 4831 130.726
CPR_70_6 o64 GND 1.85013e-015
*subckt: 71
RPR_71_0 5 7 54.2857
RPR_71_1 5 85 10.047
RPR_71_2 5 3004 11.875
RPR_71_3 9 922 58.5714
RPR_71_4 11 897 11.4286
RPR_71_5 13 901 58.5714
RPR_71_6 31 922 11.4286
RPR_71_7 45 3006 11.4286
RPR_71_8 47 3003 58.5714
RPR_71_9 49 3004 58.5714
RPR_71_10 51 894 11.4286
RPR_71_11 53 914 58.5714
RPR_71_12 71 3004 11.4286
RPR_71_13 85 87 54.2857
RPR_71_14 85 165 10.047
RPR_71_15 85 854 11.875
RPR_71_16 89 866 58.5714
RPR_71_17 91 860 11.4286
RPR_71_18 93 861 58.5714
RPR_71_19 111 866 11.4286
RPR_71_20 125 899 11.4286
RPR_71_21 127 880 58.5714
RPR_71_22 129 854 58.5714
RPR_71_23 131 882 11.4286
RPR_71_24 133 875 58.5714
RPR_71_25 151 854 11.4286
RPR_71_26 165 167 54.2857
RPR_71_27 165 213 10.047
RPR_71_28 165 814 11.875
RPR_71_29 169 826 58.5714
RPR_71_30 171 820 11.4286
RPR_71_31 173 821 58.5714
RPR_71_32 191 826 11.4286
RPR_71_33 2999 859 11.4286
RPR_71_34 3000 840 58.5714
RPR_71_35 205 814 58.5714
RPR_71_36 207 842 11.4286
RPR_71_37 209 835 58.5714
RPR_71_38 211 814 11.4286
RPR_71_39 213 231 54.2857
RPR_71_40 213 293 10.047
RPR_71_41 213 774 11.875
RPR_71_42 245 786 58.5714
RPR_71_43 247 780 11.4286
RPR_71_44 249 781 58.5714
RPR_71_45 251 786 11.4286
RPR_71_46 253 819 11.4286
RPR_71_47 271 800 58.5714
RPR_71_48 285 774 58.5714
RPR_71_49 287 802 11.4286
RPR_71_50 289 795 58.5714
RPR_71_51 291 774 11.4286
RPR_71_52 293 311 54.2857
RPR_71_53 293 373 186.751
RPR_71_54 293 391 186.751
RPR_71_55 293 405 54.2857
RPR_71_56 293 485 130.726
RPR_71_57 293 487 130.726
RPR_71_58 293 471 10.047
RPR_71_59 293 746 560.252
RPR_71_60 293 737 186.751
RPR_71_61 293 740 560.252
RPR_71_62 293 741 186.751
RPR_71_63 293 706 11.875
RPR_71_64 293 734 11.875
RPR_71_65 325 738 58.5714
RPR_71_66 327 720 11.4286
RPR_71_67 329 694 58.5714
RPR_71_68 331 738 11.4286
RPR_71_69 333 779 11.4286
RPR_71_70 351 760 58.5714
RPR_71_71 365 734 58.5714
RPR_71_72 367 762 11.4286
RPR_71_73 369 755 58.5714
RPR_71_74 371 734 11.4286
RPR_71_75 407 698 58.5714
RPR_71_76 409 680 11.4286
RPR_71_77 411 654 58.5714
RPR_71_78 413 698 11.4286
RPR_71_79 431 722 11.4286
RPR_71_80 445 715 58.5714
RPR_71_81 447 706 58.5714
RPR_71_82 449 700 11.4286
RPR_71_83 451 701 58.5714
RPR_71_84 453 706 11.4286
RPR_71_85 471 489 54.2857
RPR_71_86 471 567 10.047
RPR_71_87 471 666 11.875
RPR_71_88 491 658 58.5714
RPR_71_89 493 640 11.4286
RPR_71_90 511 614 58.5714
RPR_71_91 525 658 11.4286
RPR_71_92 527 682 11.4286
RPR_71_93 529 675 58.5714
RPR_71_94 531 666 58.5714
RPR_71_95 533 660 11.4286
RPR_71_96 551 661 58.5714
RPR_71_97 565 666 11.4286
RPR_71_98 567 569 54.2857
RPR_71_99 567 647 10.047
RPR_71_100 567 626 11.875
RPR_71_101 571 618 58.5714
RPR_71_102 573 600 11.4286
RPR_71_103 591 574 58.5714
RPR_71_104 605 618 11.4286
RPR_71_105 607 642 11.4286
RPR_71_106 609 635 58.5714
RPR_71_107 611 626 58.5714
RPR_71_108 613 620 11.4286
RPR_71_109 631 621 58.5714
RPR_71_110 645 626 11.4286
RPR_71_111 647 649 54.2857
RPR_71_112 647 727 10.047
RPR_71_113 647 586 11.875
RPR_71_114 651 578 58.5714
RPR_71_115 653 560 11.4286
RPR_71_116 671 534 58.5714
RPR_71_117 685 578 11.4286
RPR_71_118 687 602 11.4286
RPR_71_119 689 595 58.5714
RPR_71_120 691 586 58.5714
RPR_71_121 693 580 11.4286
RPR_71_122 711 581 58.5714
RPR_71_123 725 586 11.4286
RPR_71_124 727 729 54.2857
RPR_71_125 727 807 10.047
RPR_71_126 727 546 11.875
RPR_71_127 731 538 58.5714
RPR_71_128 733 520 11.4286
RPR_71_129 751 494 58.5714
RPR_71_130 765 538 11.4286
RPR_71_131 767 562 11.4286
RPR_71_132 769 555 58.5714
RPR_71_133 771 546 58.5714
RPR_71_134 773 540 11.4286
RPR_71_135 791 541 58.5714
RPR_71_136 805 546 11.4286
RPR_71_137 807 809 54.2857
RPR_71_138 807 891 10.047
RPR_71_139 807 506 11.875
RPR_71_140 811 498 58.5714
RPR_71_141 813 480 11.4286
RPR_71_142 831 454 58.5714
RPR_71_143 845 498 11.4286
RPR_71_144 847 522 11.4286
RPR_71_145 849 515 58.5714
RPR_71_146 851 506 58.5714
RPR_71_147 853 500 11.4286
RPR_71_148 871 501 58.5714
RPR_71_149 889 506 11.4286
RPR_71_150 891 893 54.2857
RPR_71_151 891 50 10.047
RPR_71_152 891 466 11.875
RPR_71_153 911 458 58.5714
RPR_71_154 2915 440 11.4286
RPR_71_155 6 414 58.5714
RPR_71_156 8 458 11.4286
RPR_71_157 10 482 11.4286
RPR_71_158 12 475 58.5714
RPR_71_159 30 466 58.5714
RPR_71_160 2916 460 11.4286
RPR_71_161 46 461 58.5714
RPR_71_162 48 466 11.4286
RPR_71_163 50 52 54.2857
RPR_71_164 50 130 54.2857
RPR_71_165 50 206 10.047
RPR_71_166 50 386 11.875
RPR_71_167 50 426 11.875
RPR_71_168 70 418 58.5714
RPR_71_169 2917 400 11.4286
RPR_71_170 86 374 58.5714
RPR_71_171 88 418 11.4286
RPR_71_172 90 442 11.4286
RPR_71_173 92 435 58.5714
RPR_71_174 110 426 58.5714
RPR_71_175 2918 420 11.4286
RPR_71_176 126 421 58.5714
RPR_71_177 128 426 11.4286
RPR_71_178 132 378 58.5714
RPR_71_179 150 360 11.4286
RPR_71_180 2921 334 58.5714
RPR_71_181 166 378 11.4286
RPR_71_182 168 402 11.4286
RPR_71_183 170 395 58.5714
RPR_71_184 172 386 58.5714
RPR_71_185 190 380 11.4286
RPR_71_186 3001 381 58.5714
RPR_71_187 3002 386 11.4286
RPR_71_188 206 208 54.2857
RPR_71_189 206 286 10.047
RPR_71_190 206 346 11.875
RPR_71_191 210 338 58.5714
RPR_71_192 212 320 11.4286
RPR_71_193 230 294 58.5714
RPR_71_194 2922 338 11.4286
RPR_71_195 246 362 11.4286
RPR_71_196 248 355 58.5714
RPR_71_197 250 346 58.5714
RPR_71_198 252 340 11.4286
RPR_71_199 270 341 58.5714
RPR_71_200 2923 346 11.4286
RPR_71_201 286 288 54.2857
RPR_71_202 286 366 30.6585
RPR_71_203 286 306 11.875
RPR_71_204 290 298 58.5714
RPR_71_205 292 280 11.4286
RPR_71_206 310 254 58.5714
RPR_71_207 2924 298 11.4286
RPR_71_208 326 322 11.4286
RPR_71_209 328 315 58.5714
RPR_71_210 330 306 58.5714
RPR_71_211 332 300 11.4286
RPR_71_212 350 301 58.5714
RPR_71_213 2925 306 11.4286
RPR_71_214 366 368 54.2857
RPR_71_215 366 446 10.047
RPR_71_216 366 266 11.875
RPR_71_217 370 258 58.5714
RPR_71_218 372 240 11.4286
RPR_71_219 390 214 58.5714
RPR_71_220 2926 258 11.4286
RPR_71_221 406 282 11.4286
RPR_71_222 408 275 58.5714
RPR_71_223 410 266 58.5714
RPR_71_224 412 260 11.4286
RPR_71_225 430 261 58.5714
RPR_71_226 2927 266 11.4286
RPR_71_227 446 448 54.2857
RPR_71_228 446 528 10.047
RPR_71_229 446 226 11.875
RPR_71_230 450 218 58.5714
RPR_71_231 452 200 11.4286
RPR_71_232 470 174 58.5714
RPR_71_233 2929 218 11.4286
RPR_71_234 486 242 11.4286
RPR_71_235 488 235 58.5714
RPR_71_236 490 226 58.5714
RPR_71_237 492 220 11.4286
RPR_71_238 510 221 58.5714
RPR_71_239 526 226 11.4286
RPR_71_240 528 530 54.2857
RPR_71_241 528 608 10.047
RPR_71_242 528 186 11.875
RPR_71_243 532 178 58.5714
RPR_71_244 550 160 11.4286
RPR_71_245 2932 134 58.5714
RPR_71_246 566 178 11.4286
RPR_71_247 568 202 11.4286
RPR_71_248 570 195 58.5714
RPR_71_249 572 186 58.5714
RPR_71_250 590 180 11.4286
RPR_71_251 2933 181 58.5714
RPR_71_252 606 186 11.4286
RPR_71_253 608 610 54.2857
RPR_71_254 608 688 10.047
RPR_71_255 608 146 11.875
RPR_71_256 612 138 58.5714
RPR_71_257 630 120 11.4286
RPR_71_258 2934 94 58.5714
RPR_71_259 646 138 11.4286
RPR_71_260 648 162 11.4286
RPR_71_261 650 155 58.5714
RPR_71_262 652 146 58.5714
RPR_71_263 670 140 11.4286
RPR_71_264 2935 141 58.5714
RPR_71_265 686 146 11.4286
RPR_71_266 688 690 54.2857
RPR_71_267 688 768 54.2857
RPR_71_268 688 66 11.875
RPR_71_269 688 106 11.875
RPR_71_270 692 98 58.5714
RPR_71_271 710 80 11.4286
RPR_71_272 2936 54 58.5714
RPR_71_273 726 98 11.4286
RPR_71_274 728 122 11.4286
RPR_71_275 730 115 58.5714
RPR_71_276 732 106 58.5714
RPR_71_277 750 100 11.4286
RPR_71_278 2937 101 58.5714
RPR_71_279 766 106 11.4286
RPR_71_280 770 58 58.5714
RPR_71_281 772 40 11.4286
RPR_71_282 790 14 58.5714
RPR_71_283 2939 58 11.4286
RPR_71_284 806 82 11.4286
RPR_71_285 808 75 58.5714
RPR_71_286 810 66 58.5714
RPR_71_287 812 60 11.4286
RPR_71_288 830 61 58.5714
RPR_71_289 846 66 11.4286
RPR_71_290 848 34 37.8425
RPR_71_291 848 892 69.1978
RPR_71_292 848 910 211.918
RPR_71_293 848 850 70
RPR_71_294 848 852 22.8572
RPR_71_295 870 34 11.4286
RPR_71_296 888 34 42.3406
RPR_71_297 888 890 201.794
RPR_71_298 890 34 129.668
RPR_71_299 892 34 58.8918
RPR_71_300 892 910 329.794
RPR_71_301 910 34 180.356
RPR_71_302 900 34 58.5714
RPR_71_303 3005 922 12.5
RPR_71_304 3005 920 14.6875
RPR_71_305 3005 3003 11.4286
RPR_71_306 3005 3006 11.4286
RPR_71_307 3004 920 14.6875
RPR_71_308 920 914 11.4286
RPR_71_309 920 894 11.4286
RPR_71_310 922 915 14.6875
RPR_71_311 915 901 11.4286
RPR_71_312 915 897 11.4286
RPR_71_313 898 866 12.5
RPR_71_314 898 874 14.6875
RPR_71_315 898 880 11.4286
RPR_71_316 898 899 11.4286
RPR_71_317 854 874 14.6875
RPR_71_318 874 875 11.4286
RPR_71_319 874 882 11.4286
RPR_71_320 866 857 14.6875
RPR_71_321 857 861 11.4286
RPR_71_322 857 860 11.4286
RPR_71_323 858 826 12.5
RPR_71_324 858 834 14.6875
RPR_71_325 858 840 11.4286
RPR_71_326 858 859 11.4286
RPR_71_327 814 834 14.6875
RPR_71_328 834 835 11.4286
RPR_71_329 834 842 11.4286
RPR_71_330 826 817 14.6875
RPR_71_331 817 821 11.4286
RPR_71_332 817 820 11.4286
RPR_71_333 818 786 12.5
RPR_71_334 818 794 14.6875
RPR_71_335 818 800 11.4286
RPR_71_336 818 819 11.4286
RPR_71_337 774 794 14.6875
RPR_71_338 794 795 11.4286
RPR_71_339 794 802 11.4286
RPR_71_340 786 777 14.6875
RPR_71_341 777 781 11.4286
RPR_71_342 777 780 11.4286
RPR_71_343 778 738 12.5
RPR_71_344 778 754 14.6875
RPR_71_345 778 760 11.4286
RPR_71_346 778 779 11.4286
RPR_71_347 734 754 14.6875
RPR_71_348 754 755 11.4286
RPR_71_349 754 762 11.4286
RPR_71_350 738 739 14.6875
RPR_71_351 739 694 11.4286
RPR_71_352 739 720 11.4286
RPR_71_353 714 698 12.5
RPR_71_354 714 697 14.6875
RPR_71_355 714 715 11.4286
RPR_71_356 714 722 11.4286
RPR_71_357 706 697 14.6875
RPR_71_358 697 701 11.4286
RPR_71_359 697 700 11.4286
RPR_71_360 698 699 14.6875
RPR_71_361 699 654 11.4286
RPR_71_362 699 680 11.4286
RPR_71_363 674 658 12.5
RPR_71_364 674 657 14.6875
RPR_71_365 674 675 11.4286
RPR_71_366 674 682 11.4286
RPR_71_367 666 657 14.6875
RPR_71_368 657 661 11.4286
RPR_71_369 657 660 11.4286
RPR_71_370 658 659 14.6875
RPR_71_371 659 614 11.4286
RPR_71_372 659 640 11.4286
RPR_71_373 634 618 12.5
RPR_71_374 634 617 14.6875
RPR_71_375 634 635 11.4286
RPR_71_376 634 642 11.4286
RPR_71_377 626 617 14.6875
RPR_71_378 617 621 11.4286
RPR_71_379 617 620 11.4286
RPR_71_380 618 619 14.6875
RPR_71_381 619 574 11.4286
RPR_71_382 619 600 11.4286
RPR_71_383 594 578 12.5
RPR_71_384 594 577 14.6875
RPR_71_385 594 595 11.4286
RPR_71_386 594 602 11.4286
RPR_71_387 586 577 14.6875
RPR_71_388 577 581 11.4286
RPR_71_389 577 580 11.4286
RPR_71_390 578 579 14.6875
RPR_71_391 579 534 11.4286
RPR_71_392 579 560 11.4286
RPR_71_393 554 538 12.5
RPR_71_394 554 537 14.6875
RPR_71_395 554 555 11.4286
RPR_71_396 554 562 11.4286
RPR_71_397 546 537 14.6875
RPR_71_398 537 541 11.4286
RPR_71_399 537 540 11.4286
RPR_71_400 538 539 14.6875
RPR_71_401 539 494 11.4286
RPR_71_402 539 520 11.4286
RPR_71_403 514 498 12.5
RPR_71_404 514 497 14.6875
RPR_71_405 514 515 11.4286
RPR_71_406 514 522 11.4286
RPR_71_407 506 497 14.6875
RPR_71_408 497 501 11.4286
RPR_71_409 497 500 11.4286
RPR_71_410 498 499 14.6875
RPR_71_411 499 454 11.4286
RPR_71_412 499 480 11.4286
RPR_71_413 474 458 12.5
RPR_71_414 474 457 14.6875
RPR_71_415 474 475 11.4286
RPR_71_416 474 482 11.4286
RPR_71_417 466 457 14.6875
RPR_71_418 457 461 11.4286
RPR_71_419 457 460 11.4286
RPR_71_420 458 459 14.6875
RPR_71_421 459 414 11.4286
RPR_71_422 459 440 11.4286
RPR_71_423 434 418 12.5
RPR_71_424 434 417 14.6875
RPR_71_425 434 435 11.4286
RPR_71_426 434 442 11.4286
RPR_71_427 426 417 14.6875
RPR_71_428 417 421 11.4286
RPR_71_429 417 420 11.4286
RPR_71_430 418 419 14.6875
RPR_71_431 419 374 11.4286
RPR_71_432 419 400 11.4286
RPR_71_433 394 378 12.5
RPR_71_434 394 377 14.6875
RPR_71_435 394 395 11.4286
RPR_71_436 394 402 11.4286
RPR_71_437 386 377 14.6875
RPR_71_438 377 381 11.4286
RPR_71_439 377 380 11.4286
RPR_71_440 378 379 14.6875
RPR_71_441 379 334 11.4286
RPR_71_442 379 360 11.4286
RPR_71_443 354 338 12.5
RPR_71_444 354 337 14.6875
RPR_71_445 354 355 11.4286
RPR_71_446 354 362 11.4286
RPR_71_447 346 337 14.6875
RPR_71_448 337 341 11.4286
RPR_71_449 337 340 11.4286
RPR_71_450 338 339 14.6875
RPR_71_451 339 294 11.4286
RPR_71_452 339 320 11.4286
RPR_71_453 314 298 12.5
RPR_71_454 314 297 14.6875
RPR_71_455 314 315 11.4286
RPR_71_456 314 322 11.4286
RPR_71_457 306 297 14.6875
RPR_71_458 297 301 11.4286
RPR_71_459 297 300 11.4286
RPR_71_460 298 299 14.6875
RPR_71_461 299 254 11.4286
RPR_71_462 299 280 11.4286
RPR_71_463 274 258 12.5
RPR_71_464 274 257 14.6875
RPR_71_465 274 275 11.4286
RPR_71_466 274 282 11.4286
RPR_71_467 266 257 14.6875
RPR_71_468 257 261 11.4286
RPR_71_469 257 260 11.4286
RPR_71_470 258 259 14.6875
RPR_71_471 259 214 11.4286
RPR_71_472 259 240 11.4286
RPR_71_473 234 218 12.5
RPR_71_474 234 217 14.6875
RPR_71_475 234 235 11.4286
RPR_71_476 234 242 11.4286
RPR_71_477 226 217 14.6875
RPR_71_478 217 221 11.4286
RPR_71_479 217 220 11.4286
RPR_71_480 218 219 14.6875
RPR_71_481 219 174 11.4286
RPR_71_482 219 200 11.4286
RPR_71_483 194 178 12.5
RPR_71_484 194 177 14.6875
RPR_71_485 194 195 11.4286
RPR_71_486 194 202 11.4286
RPR_71_487 186 177 14.6875
RPR_71_488 177 181 11.4286
RPR_71_489 177 180 11.4286
RPR_71_490 178 179 14.6875
RPR_71_491 179 134 11.4286
RPR_71_492 179 160 11.4286
RPR_71_493 154 138 12.5
RPR_71_494 154 137 14.6875
RPR_71_495 154 155 11.4286
RPR_71_496 154 162 11.4286
RPR_71_497 146 137 14.6875
RPR_71_498 137 141 11.4286
RPR_71_499 137 140 11.4286
RPR_71_500 138 139 14.6875
RPR_71_501 139 94 11.4286
RPR_71_502 139 120 11.4286
RPR_71_503 114 98 12.5
RPR_71_504 114 97 14.6875
RPR_71_505 114 115 11.4286
RPR_71_506 114 122 11.4286
RPR_71_507 106 97 14.6875
RPR_71_508 97 101 11.4286
RPR_71_509 97 100 11.4286
RPR_71_510 98 99 14.6875
RPR_71_511 99 54 11.4286
RPR_71_512 99 80 11.4286
RPR_71_513 74 58 12.5
RPR_71_514 74 57 14.6875
RPR_71_515 74 75 11.4286
RPR_71_516 74 82 11.4286
RPR_71_517 66 57 14.6875
RPR_71_518 57 61 11.4286
RPR_71_519 57 60 11.4286
RPR_71_520 58 59 14.6875
RPR_71_521 59 14 11.4286
RPR_71_522 59 40 11.4286
CPR_71_523 5 GND 1.33337e-014
CPR_71_524 85 GND 2.64848e-014
CPR_71_525 165 GND 2.64848e-014
CPR_71_526 213 GND 2.64939e-014
CPR_71_527 293 GND 5.33766e-014
CPR_71_528 471 GND 2.64848e-014
CPR_71_529 567 GND 2.64848e-014
CPR_71_530 647 GND 2.64848e-014
CPR_71_531 727 GND 2.64849e-014
CPR_71_532 807 GND 2.64848e-014
CPR_71_533 891 GND 2.64939e-014
CPR_71_534 50 GND 5.30388e-014
CPR_71_535 206 GND 2.64849e-014
CPR_71_536 286 GND 5.37119e-014
CPR_71_537 366 GND 5.37119e-014
CPR_71_538 446 GND 2.64848e-014
CPR_71_539 528 GND 2.64848e-014
CPR_71_540 608 GND 2.64939e-014
CPR_71_541 688 GND 5.30388e-014
CPR_71_542 848 GND 2.38841e-016
CPR_71_543 888 GND 1.20861e-016
CPR_71_544 890 GND 1.4292e-016
CPR_71_545 3005 GND 1.52116e-016
CPR_71_546 3004 GND 1.7197e-016
CPR_71_547 922 GND 1.57709e-016
CPR_71_548 901 GND 1.25148e-016
CPR_71_549 898 GND 1.52116e-016
CPR_71_550 854 GND 1.71223e-016
CPR_71_551 866 GND 1.5793e-016
CPR_71_552 861 GND 1.25201e-016
CPR_71_553 858 GND 1.52116e-016
CPR_71_554 814 GND 1.71224e-016
CPR_71_555 826 GND 1.57705e-016
CPR_71_556 821 GND 1.25147e-016
CPR_71_557 818 GND 1.52116e-016
CPR_71_558 774 GND 1.71975e-016
CPR_71_559 786 GND 1.56959e-016
CPR_71_560 781 GND 1.25152e-016
CPR_71_561 778 GND 1.52116e-016
CPR_71_562 734 GND 1.72197e-016
CPR_71_563 738 GND 1.56957e-016
CPR_71_564 694 GND 1.25153e-016
CPR_71_565 714 GND 1.52116e-016
CPR_71_566 706 GND 1.7197e-016
CPR_71_567 698 GND 1.57709e-016
CPR_71_568 654 GND 1.25148e-016
CPR_71_569 674 GND 1.52116e-016
CPR_71_570 666 GND 1.71223e-016
CPR_71_571 658 GND 1.5793e-016
CPR_71_572 614 GND 1.25201e-016
CPR_71_573 634 GND 1.52116e-016
CPR_71_574 626 GND 1.71224e-016
CPR_71_575 618 GND 1.57705e-016
CPR_71_576 574 GND 1.25147e-016
CPR_71_577 594 GND 1.52116e-016
CPR_71_578 586 GND 1.71975e-016
CPR_71_579 578 GND 1.56959e-016
CPR_71_580 534 GND 1.25152e-016
CPR_71_581 554 GND 1.52116e-016
CPR_71_582 546 GND 1.72197e-016
CPR_71_583 538 GND 1.56957e-016
CPR_71_584 494 GND 1.25153e-016
CPR_71_585 514 GND 1.52116e-016
CPR_71_586 506 GND 1.7197e-016
CPR_71_587 498 GND 1.57709e-016
CPR_71_588 454 GND 1.25148e-016
CPR_71_589 474 GND 1.52116e-016
CPR_71_590 466 GND 1.71223e-016
CPR_71_591 458 GND 1.5793e-016
CPR_71_592 414 GND 1.25201e-016
CPR_71_593 434 GND 1.52116e-016
CPR_71_594 426 GND 1.71224e-016
CPR_71_595 418 GND 1.57705e-016
CPR_71_596 374 GND 1.25147e-016
CPR_71_597 394 GND 1.52116e-016
CPR_71_598 386 GND 1.71975e-016
CPR_71_599 378 GND 1.56957e-016
CPR_71_600 334 GND 1.25148e-016
CPR_71_601 354 GND 1.52116e-016
CPR_71_602 346 GND 1.72197e-016
CPR_71_603 338 GND 1.56959e-016
CPR_71_604 294 GND 1.25152e-016
CPR_71_605 314 GND 1.52116e-016
CPR_71_606 306 GND 1.7197e-016
CPR_71_607 298 GND 1.57709e-016
CPR_71_608 254 GND 1.25148e-016
CPR_71_609 274 GND 1.52116e-016
CPR_71_610 266 GND 1.7197e-016
CPR_71_611 258 GND 1.57709e-016
CPR_71_612 214 GND 1.25148e-016
CPR_71_613 234 GND 1.52116e-016
CPR_71_614 226 GND 1.71224e-016
CPR_71_615 218 GND 1.5793e-016
CPR_71_616 174 GND 1.25201e-016
CPR_71_617 194 GND 1.52116e-016
CPR_71_618 186 GND 1.71223e-016
CPR_71_619 178 GND 1.57706e-016
CPR_71_620 134 GND 1.25153e-016
CPR_71_621 154 GND 1.52116e-016
CPR_71_622 146 GND 1.71975e-016
CPR_71_623 138 GND 1.56957e-016
CPR_71_624 94 GND 1.25148e-016
CPR_71_625 114 GND 1.52116e-016
CPR_71_626 106 GND 1.72197e-016
CPR_71_627 98 GND 1.56959e-016
CPR_71_628 54 GND 1.25152e-016
CPR_71_629 74 GND 1.52116e-016
CPR_71_630 66 GND 1.7197e-016
CPR_71_631 58 GND 1.57709e-016
CPR_71_632 14 GND 1.25148e-016
CPR_71_633 34 GND 3.65042e-016
*subckt: 72
*subckt: 73
CPR_73 5886 gnd 3.306e-014
*subckt: 74
CPR_74 5562 gnd 1.59596e-014
*subckt: 75
RPR_75_0 885 887 54.2857
RPR_75_1 885 927 10.047
RPR_75_2 885 925 11.875
RPR_75_3 925 1510 58.5714
RPR_75_4 925 2960 11.4286
RPR_75_5 927 929 54.2857
RPR_75_6 927 1007 10.047
RPR_75_7 927 2762 11.875
RPR_75_8 931 2740 58.5714
RPR_75_9 933 2738 11.4286
RPR_75_10 951 2739 58.5714
RPR_75_11 965 2740 11.4286
RPR_75_12 967 2734 11.4286
RPR_75_13 969 2754 58.5714
RPR_75_14 971 2762 58.5714
RPR_75_15 973 2746 11.4286
RPR_75_16 991 2737 58.5714
RPR_75_17 1005 2762 11.4286
RPR_75_18 1007 1009 54.2857
RPR_75_19 1007 1087 10.047
RPR_75_20 1007 2722 11.875
RPR_75_21 1011 2700 58.5714
RPR_75_22 1013 2698 11.4286
RPR_75_23 1031 2699 58.5714
RPR_75_24 1045 2700 11.4286
RPR_75_25 1047 2694 11.4286
RPR_75_26 1049 2714 58.5714
RPR_75_27 1051 2722 58.5714
RPR_75_28 1053 2706 11.4286
RPR_75_29 1071 2697 58.5714
RPR_75_30 1085 2722 11.4286
RPR_75_31 1087 1089 54.2857
RPR_75_32 1087 1167 10.047
RPR_75_33 1087 2682 11.875
RPR_75_34 1091 2660 58.5714
RPR_75_35 1093 2658 11.4286
RPR_75_36 1111 2659 58.5714
RPR_75_37 1125 2660 11.4286
RPR_75_38 1127 2654 11.4286
RPR_75_39 1129 2674 58.5714
RPR_75_40 1131 2682 58.5714
RPR_75_41 1133 2666 11.4286
RPR_75_42 1151 2657 58.5714
RPR_75_43 1165 2682 11.4286
RPR_75_44 1167 1169 54.2857
RPR_75_45 1167 1247 10.047
RPR_75_46 1167 2642 11.875
RPR_75_47 1171 2620 58.5714
RPR_75_48 1173 2618 11.4286
RPR_75_49 1191 2619 58.5714
RPR_75_50 1205 2620 11.4286
RPR_75_51 1207 2614 11.4286
RPR_75_52 1209 2634 58.5714
RPR_75_53 1211 2642 58.5714
RPR_75_54 1213 2626 11.4286
RPR_75_55 1231 2617 58.5714
RPR_75_56 1245 2642 11.4286
RPR_75_57 1247 1249 54.2857
RPR_75_58 1247 1327 10.047
RPR_75_59 1247 1682 11.875
RPR_75_60 1251 1660 58.5714
RPR_75_61 1253 1658 11.4286
RPR_75_62 1271 1659 58.5714
RPR_75_63 1285 1660 11.4286
RPR_75_64 1287 1654 11.4286
RPR_75_65 1289 1674 58.5714
RPR_75_66 1291 1682 58.5714
RPR_75_67 1293 1666 11.4286
RPR_75_68 1311 1657 58.5714
RPR_75_69 1325 1682 11.4286
RPR_75_70 1327 1329 54.2857
RPR_75_71 1327 1407 54.2857
RPR_75_72 1327 1485 10.047
RPR_75_73 1327 1602 11.875
RPR_75_74 1327 1642 11.875
RPR_75_75 1331 1620 58.5714
RPR_75_76 1333 1618 11.4286
RPR_75_77 1351 1619 58.5714
RPR_75_78 1365 1620 11.4286
RPR_75_79 1367 1614 11.4286
RPR_75_80 1369 1634 58.5714
RPR_75_81 1371 1642 58.5714
RPR_75_82 1373 1626 11.4286
RPR_75_83 1391 1617 58.5714
RPR_75_84 1405 1642 11.4286
RPR_75_85 1409 1580 58.5714
RPR_75_86 1411 1578 11.4286
RPR_75_87 1413 1579 58.5714
RPR_75_88 1431 1580 11.4286
RPR_75_89 1445 1574 11.4286
RPR_75_90 1447 1594 58.5714
RPR_75_91 1449 1602 58.5714
RPR_75_92 1451 1586 11.4286
RPR_75_93 1453 1577 58.5714
RPR_75_94 1471 1602 11.4286
RPR_75_95 1485 1487 54.2857
RPR_75_96 1485 1565 10.047
RPR_75_97 1485 1562 11.875
RPR_75_98 1489 1540 58.5714
RPR_75_99 1491 1538 11.4286
RPR_75_100 1493 1539 58.5714
RPR_75_101 1511 1540 11.4286
RPR_75_102 1525 1534 11.4286
RPR_75_103 1527 1554 58.5714
RPR_75_104 1529 1562 58.5714
RPR_75_105 1531 1546 11.4286
RPR_75_106 1533 1537 58.5714
RPR_75_107 1551 1562 11.4286
RPR_75_108 1565 1567 54.2857
RPR_75_109 1565 1645 31.1895
RPR_75_110 1565 1522 11.875
RPR_75_111 1569 1500 58.5714
RPR_75_112 1571 1498 11.4286
RPR_75_113 1573 1499 58.5714
RPR_75_114 1591 1500 11.4286
RPR_75_115 1605 1494 11.4286
RPR_75_116 1607 1514 58.5714
RPR_75_117 1609 1522 58.5714
RPR_75_118 1611 1506 11.4286
RPR_75_119 1613 1497 58.5714
RPR_75_120 1631 1522 11.4286
RPR_75_121 1645 1647 54.2857
RPR_75_122 1645 2645 10.047
RPR_75_123 1645 1482 11.875
RPR_75_124 1649 1460 58.5714
RPR_75_125 1651 1458 11.4286
RPR_75_126 1653 1459 58.5714
RPR_75_127 1671 1460 11.4286
RPR_75_128 2605 1454 11.4286
RPR_75_129 2607 1474 58.5714
RPR_75_130 2609 1482 58.5714
RPR_75_131 2611 1466 11.4286
RPR_75_132 2613 1457 58.5714
RPR_75_133 2631 1482 11.4286
RPR_75_134 2645 2647 54.2857
RPR_75_135 2645 2725 10.047
RPR_75_136 2645 1442 11.875
RPR_75_137 2649 1420 58.5714
RPR_75_138 2651 1418 11.4286
RPR_75_139 2653 1419 58.5714
RPR_75_140 2671 1420 11.4286
RPR_75_141 2685 1414 11.4286
RPR_75_142 2687 1434 58.5714
RPR_75_143 2689 1442 58.5714
RPR_75_144 2691 1426 11.4286
RPR_75_145 2693 1417 58.5714
RPR_75_146 2711 1442 11.4286
RPR_75_147 2725 2727 54.2857
RPR_75_148 2725 932 54.2857
RPR_75_149 2725 1010 10.047
RPR_75_150 2725 1362 11.875
RPR_75_151 2725 1402 11.875
RPR_75_152 2729 1380 58.5714
RPR_75_153 2731 1378 11.4286
RPR_75_154 2733 1379 58.5714
RPR_75_155 2751 1380 11.4286
RPR_75_156 2940 1374 11.4286
RPR_75_157 886 1394 58.5714
RPR_75_158 2941 1402 58.5714
RPR_75_159 926 1386 11.4286
RPR_75_160 928 1377 58.5714
RPR_75_161 930 1402 11.4286
RPR_75_162 950 1340 58.5714
RPR_75_163 2942 1338 11.4286
RPR_75_164 966 1339 58.5714
RPR_75_165 968 1340 11.4286
RPR_75_166 970 1334 11.4286
RPR_75_167 972 1354 58.5714
RPR_75_168 990 1362 58.5714
RPR_75_169 2945 1346 11.4286
RPR_75_170 1006 1337 58.5714
RPR_75_171 1008 1362 11.4286
RPR_75_172 1010 1012 54.2857
RPR_75_173 1010 1090 10.047
RPR_75_174 1010 1322 11.875
RPR_75_175 1030 1300 58.5714
RPR_75_176 2946 1298 11.4286
RPR_75_177 1046 1299 58.5714
RPR_75_178 1048 1300 11.4286
RPR_75_179 1050 1294 11.4286
RPR_75_180 1052 1314 58.5714
RPR_75_181 1070 1322 58.5714
RPR_75_182 2947 1306 11.4286
RPR_75_183 1086 1297 58.5714
RPR_75_184 1088 1322 11.4286
RPR_75_185 1090 1092 54.2857
RPR_75_186 1090 1172 10.047
RPR_75_187 1090 1282 11.875
RPR_75_188 1110 1260 58.5714
RPR_75_189 2949 1258 11.4286
RPR_75_190 1126 1259 58.5714
RPR_75_191 1128 1260 11.4286
RPR_75_192 1130 1254 11.4286
RPR_75_193 1132 1274 58.5714
RPR_75_194 1150 1282 58.5714
RPR_75_195 1166 1266 11.4286
RPR_75_196 1168 1257 58.5714
RPR_75_197 1170 1282 11.4286
RPR_75_198 1172 1190 54.2857
RPR_75_199 1172 1252 10.047
RPR_75_200 1172 1242 11.875
RPR_75_201 2950 1220 58.5714
RPR_75_202 1206 1218 11.4286
RPR_75_203 1208 1219 58.5714
RPR_75_204 1210 1220 11.4286
RPR_75_205 1212 1214 11.4286
RPR_75_206 1230 1234 58.5714
RPR_75_207 2951 1242 58.5714
RPR_75_208 1246 1226 11.4286
RPR_75_209 1248 1217 58.5714
RPR_75_210 1250 1242 11.4286
RPR_75_211 1252 1270 54.2857
RPR_75_212 1252 1332 10.047
RPR_75_213 1252 1202 11.875
RPR_75_214 2954 1180 58.5714
RPR_75_215 1286 1178 11.4286
RPR_75_216 1288 1179 58.5714
RPR_75_217 1290 1180 11.4286
RPR_75_218 1292 1174 11.4286
RPR_75_219 1310 1194 58.5714
RPR_75_220 2955 1202 58.5714
RPR_75_221 1326 1186 11.4286
RPR_75_222 1328 1177 58.5714
RPR_75_223 1330 1202 11.4286
RPR_75_224 1332 1350 54.2857
RPR_75_225 1332 1430 10.047
RPR_75_226 1332 1162 11.875
RPR_75_227 2957 1140 58.5714
RPR_75_228 1366 1138 11.4286
RPR_75_229 1368 1139 58.5714
RPR_75_230 1370 1140 11.4286
RPR_75_231 1372 1134 11.4286
RPR_75_232 1390 1154 58.5714
RPR_75_233 1406 1162 58.5714
RPR_75_234 1408 1146 11.4286
RPR_75_235 1410 1137 58.5714
RPR_75_236 1412 1162 11.4286
RPR_75_237 1430 2958 54.2857
RPR_75_238 1430 1122 11.875
RPR_75_239 1446 1100 58.5714
RPR_75_240 1448 1098 11.4286
RPR_75_241 1450 1099 58.5714
RPR_75_242 1452 1100 11.4286
RPR_75_243 1470 1094 11.4286
RPR_75_244 2959 1114 58.5714
RPR_75_245 1486 1122 58.5714
RPR_75_246 1488 1106 11.4286
RPR_75_247 1490 1097 58.5714
RPR_75_248 1492 1122 11.4286
RPR_75_249 1526 1528 54.2857
RPR_75_250 1526 1606 54.2857
RPR_75_251 1526 2995 10.047
RPR_75_252 1526 1042 11.875
RPR_75_253 1526 1082 11.875
RPR_75_254 1530 1060 58.5714
RPR_75_255 1532 1058 11.4286
RPR_75_256 1550 1059 58.5714
RPR_75_257 2963 1060 11.4286
RPR_75_258 1566 1054 11.4286
RPR_75_259 1568 1074 58.5714
RPR_75_260 1570 1082 58.5714
RPR_75_261 1572 1066 11.4286
RPR_75_262 1590 1057 58.5714
RPR_75_263 2964 1082 11.4286
RPR_75_264 1608 1020 58.5714
RPR_75_265 1610 1018 11.4286
RPR_75_266 1612 1019 58.5714
RPR_75_267 1630 1020 11.4286
RPR_75_268 2965 1014 11.4286
RPR_75_269 1646 1034 58.5714
RPR_75_270 1648 1042 58.5714
RPR_75_271 1650 1026 11.4286
RPR_75_272 1652 1017 58.5714
RPR_75_273 1670 1042 11.4286
RPR_75_274 2995 2606 54.2857
RPR_75_275 2995 2686 10.047
RPR_75_276 2995 1002 11.875
RPR_75_277 2608 980 58.5714
RPR_75_278 2610 978 11.4286
RPR_75_279 2612 979 58.5714
RPR_75_280 2630 980 11.4286
RPR_75_281 2646 974 11.4286
RPR_75_282 2648 994 58.5714
RPR_75_283 2650 1002 58.5714
RPR_75_284 2652 986 11.4286
RPR_75_285 2670 977 58.5714
RPR_75_286 2996 1002 11.4286
RPR_75_287 2686 2688 54.2857
RPR_75_288 2686 962 11.875
RPR_75_289 2690 940 58.5714
RPR_75_290 2692 940 42.3406
RPR_75_291 2692 2710 201.794
RPR_75_292 2710 940 129.668
RPR_75_293 2997 940 11.4286
RPR_75_294 2726 934 11.4286
RPR_75_295 2728 954 58.5714
RPR_75_296 2730 962 58.5714
RPR_75_297 2732 946 11.4286
RPR_75_298 2750 937 58.5714
RPR_75_299 906 962 11.4286
RPR_75_300 2760 2740 12.5
RPR_75_301 2760 2755 14.6875
RPR_75_302 2760 2754 11.4286
RPR_75_303 2760 2734 11.4286
RPR_75_304 2762 2755 14.6875
RPR_75_305 2755 2737 11.4286
RPR_75_306 2755 2746 11.4286
RPR_75_307 2740 2741 14.6875
RPR_75_308 2741 2739 11.4286
RPR_75_309 2741 2738 11.4286
RPR_75_310 2720 2700 12.5
RPR_75_311 2720 2715 14.6875
RPR_75_312 2720 2714 11.4286
RPR_75_313 2720 2694 11.4286
RPR_75_314 2722 2715 14.6875
RPR_75_315 2715 2697 11.4286
RPR_75_316 2715 2706 11.4286
RPR_75_317 2700 2701 14.6875
RPR_75_318 2701 2699 11.4286
RPR_75_319 2701 2698 11.4286
RPR_75_320 2680 2660 12.5
RPR_75_321 2680 2675 14.6875
RPR_75_322 2680 2674 11.4286
RPR_75_323 2680 2654 11.4286
RPR_75_324 2682 2675 14.6875
RPR_75_325 2675 2657 11.4286
RPR_75_326 2675 2666 11.4286
RPR_75_327 2660 2661 14.6875
RPR_75_328 2661 2659 11.4286
RPR_75_329 2661 2658 11.4286
RPR_75_330 2640 2620 12.5
RPR_75_331 2640 2635 14.6875
RPR_75_332 2640 2634 11.4286
RPR_75_333 2640 2614 11.4286
RPR_75_334 2642 2635 14.6875
RPR_75_335 2635 2617 11.4286
RPR_75_336 2635 2626 11.4286
RPR_75_337 2620 2621 14.6875
RPR_75_338 2621 2619 11.4286
RPR_75_339 2621 2618 11.4286
RPR_75_340 1680 1660 12.5
RPR_75_341 1680 1675 14.6875
RPR_75_342 1680 1674 11.4286
RPR_75_343 1680 1654 11.4286
RPR_75_344 1682 1675 14.6875
RPR_75_345 1675 1657 11.4286
RPR_75_346 1675 1666 11.4286
RPR_75_347 1660 1661 14.6875
RPR_75_348 1661 1659 11.4286
RPR_75_349 1661 1658 11.4286
RPR_75_350 1640 1620 12.5
RPR_75_351 1640 1635 14.6875
RPR_75_352 1640 1634 11.4286
RPR_75_353 1640 1614 11.4286
RPR_75_354 1642 1635 14.6875
RPR_75_355 1635 1617 11.4286
RPR_75_356 1635 1626 11.4286
RPR_75_357 1620 1621 14.6875
RPR_75_358 1621 1619 11.4286
RPR_75_359 1621 1618 11.4286
RPR_75_360 1600 1580 12.5
RPR_75_361 1600 1595 14.6875
RPR_75_362 1600 1594 11.4286
RPR_75_363 1600 1574 11.4286
RPR_75_364 1602 1595 14.6875
RPR_75_365 1595 1577 11.4286
RPR_75_366 1595 1586 11.4286
RPR_75_367 1580 1581 14.6875
RPR_75_368 1581 1579 11.4286
RPR_75_369 1581 1578 11.4286
RPR_75_370 1560 1540 12.5
RPR_75_371 1560 1555 14.6875
RPR_75_372 1560 1554 11.4286
RPR_75_373 1560 1534 11.4286
RPR_75_374 1562 1555 14.6875
RPR_75_375 1555 1537 11.4286
RPR_75_376 1555 1546 11.4286
RPR_75_377 1540 1541 14.6875
RPR_75_378 1541 1539 11.4286
RPR_75_379 1541 1538 11.4286
RPR_75_380 1520 1500 12.5
RPR_75_381 1520 1515 14.6875
RPR_75_382 1520 1514 11.4286
RPR_75_383 1520 1494 11.4286
RPR_75_384 1522 1515 14.6875
RPR_75_385 1515 1497 11.4286
RPR_75_386 1515 1506 11.4286
RPR_75_387 1500 1501 14.6875
RPR_75_388 1501 1499 11.4286
RPR_75_389 1501 1498 11.4286
RPR_75_390 1480 1460 12.5
RPR_75_391 1480 1475 14.6875
RPR_75_392 1480 1474 11.4286
RPR_75_393 1480 1454 11.4286
RPR_75_394 1482 1475 14.6875
RPR_75_395 1475 1457 11.4286
RPR_75_396 1475 1466 11.4286
RPR_75_397 1460 1461 14.6875
RPR_75_398 1461 1459 11.4286
RPR_75_399 1461 1458 11.4286
RPR_75_400 1440 1420 12.5
RPR_75_401 1440 1435 14.6875
RPR_75_402 1440 1434 11.4286
RPR_75_403 1440 1414 11.4286
RPR_75_404 1442 1435 14.6875
RPR_75_405 1435 1417 11.4286
RPR_75_406 1435 1426 11.4286
RPR_75_407 1420 1421 14.6875
RPR_75_408 1421 1419 11.4286
RPR_75_409 1421 1418 11.4286
RPR_75_410 1400 1380 12.5
RPR_75_411 1400 1395 14.6875
RPR_75_412 1400 1394 11.4286
RPR_75_413 1400 1374 11.4286
RPR_75_414 1402 1395 14.6875
RPR_75_415 1395 1377 11.4286
RPR_75_416 1395 1386 11.4286
RPR_75_417 1380 1381 14.6875
RPR_75_418 1381 1379 11.4286
RPR_75_419 1381 1378 11.4286
RPR_75_420 1360 1340 12.5
RPR_75_421 1360 1355 14.6875
RPR_75_422 1360 1354 11.4286
RPR_75_423 1360 1334 11.4286
RPR_75_424 1362 1355 14.6875
RPR_75_425 1355 1337 11.4286
RPR_75_426 1355 1346 11.4286
RPR_75_427 1340 1341 14.6875
RPR_75_428 1341 1339 11.4286
RPR_75_429 1341 1338 11.4286
RPR_75_430 1320 1300 12.5
RPR_75_431 1320 1315 14.6875
RPR_75_432 1320 1314 11.4286
RPR_75_433 1320 1294 11.4286
RPR_75_434 1322 1315 14.6875
RPR_75_435 1315 1297 11.4286
RPR_75_436 1315 1306 11.4286
RPR_75_437 1300 1301 14.6875
RPR_75_438 1301 1299 11.4286
RPR_75_439 1301 1298 11.4286
RPR_75_440 1280 1260 12.5
RPR_75_441 1280 1275 14.6875
RPR_75_442 1280 1274 11.4286
RPR_75_443 1280 1254 11.4286
RPR_75_444 1282 1275 14.6875
RPR_75_445 1275 1257 11.4286
RPR_75_446 1275 1266 11.4286
RPR_75_447 1260 1261 14.6875
RPR_75_448 1261 1259 11.4286
RPR_75_449 1261 1258 11.4286
RPR_75_450 1240 1220 12.5
RPR_75_451 1240 1235 14.6875
RPR_75_452 1240 1234 11.4286
RPR_75_453 1240 1214 11.4286
RPR_75_454 1242 1235 14.6875
RPR_75_455 1235 1217 11.4286
RPR_75_456 1235 1226 11.4286
RPR_75_457 1220 1221 14.6875
RPR_75_458 1221 1219 11.4286
RPR_75_459 1221 1218 11.4286
RPR_75_460 1200 1180 12.5
RPR_75_461 1200 1195 14.6875
RPR_75_462 1200 1194 11.4286
RPR_75_463 1200 1174 11.4286
RPR_75_464 1202 1195 14.6875
RPR_75_465 1195 1177 11.4286
RPR_75_466 1195 1186 11.4286
RPR_75_467 1180 1181 14.6875
RPR_75_468 1181 1179 11.4286
RPR_75_469 1181 1178 11.4286
RPR_75_470 1160 1140 12.5
RPR_75_471 1160 1155 14.6875
RPR_75_472 1160 1154 11.4286
RPR_75_473 1160 1134 11.4286
RPR_75_474 1162 1155 14.6875
RPR_75_475 1155 1137 11.4286
RPR_75_476 1155 1146 11.4286
RPR_75_477 1140 1141 14.6875
RPR_75_478 1141 1139 11.4286
RPR_75_479 1141 1138 11.4286
RPR_75_480 1120 1100 12.5
RPR_75_481 1120 1115 14.6875
RPR_75_482 1120 1114 11.4286
RPR_75_483 1120 1094 11.4286
RPR_75_484 1122 1115 14.6875
RPR_75_485 1115 1097 11.4286
RPR_75_486 1115 1106 11.4286
RPR_75_487 1100 1101 14.6875
RPR_75_488 1101 1099 11.4286
RPR_75_489 1101 1098 11.4286
RPR_75_490 1080 1060 12.5
RPR_75_491 1080 1075 14.6875
RPR_75_492 1080 1074 11.4286
RPR_75_493 1080 1054 11.4286
RPR_75_494 1082 1075 14.6875
RPR_75_495 1075 1057 11.4286
RPR_75_496 1075 1066 11.4286
RPR_75_497 1060 1061 14.6875
RPR_75_498 1061 1059 11.4286
RPR_75_499 1061 1058 11.4286
RPR_75_500 1040 1020 12.5
RPR_75_501 1040 1035 14.6875
RPR_75_502 1040 1034 11.4286
RPR_75_503 1040 1014 11.4286
RPR_75_504 1042 1035 14.6875
RPR_75_505 1035 1017 11.4286
RPR_75_506 1035 1026 11.4286
RPR_75_507 1020 1021 14.6875
RPR_75_508 1021 1019 11.4286
RPR_75_509 1021 1018 11.4286
RPR_75_510 1000 980 12.5
RPR_75_511 1000 995 14.6875
RPR_75_512 1000 994 11.4286
RPR_75_513 1000 974 11.4286
RPR_75_514 1002 995 14.6875
RPR_75_515 995 977 11.4286
RPR_75_516 995 986 11.4286
RPR_75_517 980 981 14.6875
RPR_75_518 981 979 11.4286
RPR_75_519 981 978 11.4286
RPR_75_520 960 940 12.5
RPR_75_521 960 955 14.6875
RPR_75_522 960 954 11.4286
RPR_75_523 960 934 11.4286
RPR_75_524 962 955 14.6875
RPR_75_525 955 937 11.4286
RPR_75_526 955 946 11.4286
CPR_75_527 885 GND 2.64848e-014
CPR_75_528 925 GND 1.71224e-016
CPR_75_529 927 GND 2.64848e-014
CPR_75_530 1007 GND 2.64848e-014
CPR_75_531 1087 GND 2.64848e-014
CPR_75_532 1167 GND 2.64849e-014
CPR_75_533 1247 GND 2.64939e-014
CPR_75_534 1327 GND 5.30388e-014
CPR_75_535 1485 GND 2.64848e-014
CPR_75_536 1565 GND 5.44133e-014
CPR_75_537 1645 GND 5.44165e-014
CPR_75_538 2645 GND 2.64971e-014
CPR_75_539 2725 GND 5.30388e-014
CPR_75_540 1010 GND 2.64848e-014
CPR_75_541 1090 GND 2.64848e-014
CPR_75_542 1172 GND 2.64848e-014
CPR_75_543 1252 GND 2.64848e-014
CPR_75_544 1332 GND 2.64939e-014
CPR_75_545 1430 GND 2.6494e-014
CPR_75_546 1526 GND 5.30388e-014
CPR_75_547 2995 GND 2.64848e-014
CPR_75_548 2686 GND 1.33338e-014
CPR_75_549 2692 GND 1.20834e-016
CPR_75_550 2710 GND 1.42859e-016
CPR_75_551 2760 GND 1.52116e-016
CPR_75_552 2762 GND 1.71228e-016
CPR_75_553 2740 GND 1.5793e-016
CPR_75_554 2739 GND 1.2519e-016
CPR_75_555 2720 GND 1.52116e-016
CPR_75_556 2722 GND 1.72197e-016
CPR_75_557 2700 GND 1.56958e-016
CPR_75_558 2699 GND 1.25185e-016
CPR_75_559 2680 GND 1.52116e-016
CPR_75_560 2682 GND 1.72264e-016
CPR_75_561 2660 GND 1.5696e-016
CPR_75_562 2659 GND 1.25185e-016
CPR_75_563 2640 GND 1.52116e-016
CPR_75_564 2642 GND 1.72202e-016
CPR_75_565 2620 GND 1.5793e-016
CPR_75_566 2619 GND 1.25201e-016
CPR_75_567 1680 GND 1.52116e-016
CPR_75_568 1682 GND 1.71229e-016
CPR_75_569 1660 GND 1.57996e-016
CPR_75_570 1659 GND 1.25147e-016
CPR_75_571 1640 GND 1.52116e-016
CPR_75_572 1642 GND 1.71228e-016
CPR_75_573 1620 GND 1.5793e-016
CPR_75_574 1619 GND 1.2519e-016
CPR_75_575 1600 GND 1.52116e-016
CPR_75_576 1602 GND 1.71224e-016
CPR_75_577 1580 GND 1.57971e-016
CPR_75_578 1579 GND 1.2519e-016
CPR_75_579 1560 GND 1.52116e-016
CPR_75_580 1562 GND 1.72239e-016
CPR_75_581 1540 GND 1.57971e-016
CPR_75_582 1539 GND 1.25191e-016
CPR_75_583 1520 GND 1.52116e-016
CPR_75_584 1522 GND 1.71228e-016
CPR_75_585 1500 GND 1.56957e-016
CPR_75_586 1499 GND 1.2519e-016
CPR_75_587 1480 GND 1.52116e-016
CPR_75_588 1482 GND 1.71229e-016
CPR_75_589 1460 GND 1.57996e-016
CPR_75_590 1459 GND 1.25147e-016
CPR_75_591 1440 GND 1.52116e-016
CPR_75_592 1442 GND 1.71228e-016
CPR_75_593 1420 GND 1.5793e-016
CPR_75_594 1419 GND 1.2519e-016
CPR_75_595 1400 GND 1.52116e-016
CPR_75_596 1402 GND 1.71975e-016
CPR_75_597 1380 GND 1.56957e-016
CPR_75_598 1379 GND 1.25148e-016
CPR_75_599 1360 GND 1.52116e-016
CPR_75_600 1362 GND 1.72197e-016
CPR_75_601 1340 GND 1.56957e-016
CPR_75_602 1339 GND 1.25153e-016
CPR_75_603 1320 GND 1.52116e-016
CPR_75_604 1322 GND 1.71228e-016
CPR_75_605 1300 GND 1.56957e-016
CPR_75_606 1299 GND 1.2519e-016
CPR_75_607 1280 GND 1.52116e-016
CPR_75_608 1282 GND 1.72239e-016
CPR_75_609 1260 GND 1.57971e-016
CPR_75_610 1259 GND 1.25148e-016
CPR_75_611 1240 GND 1.52116e-016
CPR_75_612 1242 GND 1.72239e-016
CPR_75_613 1220 GND 1.56959e-016
CPR_75_614 1219 GND 1.2519e-016
CPR_75_615 1200 GND 1.52116e-016
CPR_75_616 1202 GND 1.72197e-016
CPR_75_617 1180 GND 1.56958e-016
CPR_75_618 1179 GND 1.25185e-016
CPR_75_619 1160 GND 1.52116e-016
CPR_75_620 1162 GND 1.72264e-016
CPR_75_621 1140 GND 1.5696e-016
CPR_75_622 1139 GND 1.25185e-016
CPR_75_623 1120 GND 1.52116e-016
CPR_75_624 1122 GND 1.72202e-016
CPR_75_625 1100 GND 1.5793e-016
CPR_75_626 1099 GND 1.25201e-016
CPR_75_627 1080 GND 1.52116e-016
CPR_75_628 1082 GND 1.71223e-016
CPR_75_629 1060 GND 1.5793e-016
CPR_75_630 1059 GND 1.25201e-016
CPR_75_631 1040 GND 1.52116e-016
CPR_75_632 1042 GND 1.71224e-016
CPR_75_633 1020 GND 1.57705e-016
CPR_75_634 1019 GND 1.25147e-016
CPR_75_635 1000 GND 1.52116e-016
CPR_75_636 1002 GND 1.71975e-016
CPR_75_637 980 GND 1.56959e-016
CPR_75_638 979 GND 1.25152e-016
CPR_75_639 960 GND 1.52116e-016
CPR_75_640 962 GND 1.72197e-016
CPR_75_641 940 GND 2.75414e-016
*subckt: 76
RPR_76_0 1685 1687 54.2857
RPR_76_1 1685 1765 10.047
RPR_76_2 1685 2602 11.875
RPR_76_3 1689 2580 58.5714
RPR_76_4 1691 2578 11.4286
RPR_76_5 1693 2579 58.5714
RPR_76_6 1711 2580 11.4286
RPR_76_7 1725 2574 11.4286
RPR_76_8 1727 2594 58.5714
RPR_76_9 1729 2602 58.5714
RPR_76_10 1731 2586 11.4286
RPR_76_11 1733 2577 58.5714
RPR_76_12 1751 2602 11.4286
RPR_76_13 1765 1767 54.2857
RPR_76_14 1765 1845 10.047
RPR_76_15 1765 2562 11.875
RPR_76_16 1769 2540 58.5714
RPR_76_17 1771 2538 11.4286
RPR_76_18 1773 2539 58.5714
RPR_76_19 1791 2540 11.4286
RPR_76_20 1805 2534 11.4286
RPR_76_21 1807 2554 58.5714
RPR_76_22 1809 2562 58.5714
RPR_76_23 1811 2546 11.4286
RPR_76_24 1813 2537 58.5714
RPR_76_25 1831 2562 11.4286
RPR_76_26 1845 1847 54.2857
RPR_76_27 1845 1925 10.047
RPR_76_28 1845 2522 11.875
RPR_76_29 1849 2500 58.5714
RPR_76_30 1851 2498 11.4286
RPR_76_31 1853 2499 58.5714
RPR_76_32 1871 2500 11.4286
RPR_76_33 1885 2494 11.4286
RPR_76_34 1887 2514 58.5714
RPR_76_35 1889 2522 58.5714
RPR_76_36 1891 2506 11.4286
RPR_76_37 1893 2497 58.5714
RPR_76_38 1911 2522 11.4286
RPR_76_39 1925 1927 54.2857
RPR_76_40 1925 2005 10.047
RPR_76_41 1925 2482 11.875
RPR_76_42 1929 2460 58.5714
RPR_76_43 1931 2458 11.4286
RPR_76_44 1933 2459 58.5714
RPR_76_45 1951 2460 11.4286
RPR_76_46 1965 2454 11.4286
RPR_76_47 1967 2474 58.5714
RPR_76_48 1969 2482 58.5714
RPR_76_49 1971 2466 11.4286
RPR_76_50 1973 2457 58.5714
RPR_76_51 1991 2482 11.4286
RPR_76_52 2005 2007 54.2857
RPR_76_53 2005 2085 10.047
RPR_76_54 2005 2442 11.875
RPR_76_55 2009 2420 58.5714
RPR_76_56 2011 2418 11.4286
RPR_76_57 2013 2419 58.5714
RPR_76_58 2031 2420 11.4286
RPR_76_59 2045 2414 11.4286
RPR_76_60 2047 2434 58.5714
RPR_76_61 2049 2442 58.5714
RPR_76_62 2051 2426 11.4286
RPR_76_63 2053 2417 58.5714
RPR_76_64 2071 2442 11.4286
RPR_76_65 2085 2087 54.2857
RPR_76_66 2085 2165 10.047
RPR_76_67 2085 2402 11.875
RPR_76_68 2089 2380 58.5714
RPR_76_69 2091 2378 11.4286
RPR_76_70 2093 2379 58.5714
RPR_76_71 2111 2380 11.4286
RPR_76_72 2125 2374 11.4286
RPR_76_73 2127 2394 58.5714
RPR_76_74 2129 2402 58.5714
RPR_76_75 2131 2386 11.4286
RPR_76_76 2133 2377 58.5714
RPR_76_77 2151 2402 11.4286
RPR_76_78 2165 2167 54.2857
RPR_76_79 2165 2245 10.047
RPR_76_80 2165 2362 11.875
RPR_76_81 2169 2340 58.5714
RPR_76_82 2171 2338 11.4286
RPR_76_83 2173 2339 58.5714
RPR_76_84 2191 2340 11.4286
RPR_76_85 2205 2334 11.4286
RPR_76_86 2207 2354 58.5714
RPR_76_87 2209 2362 58.5714
RPR_76_88 2211 2346 11.4286
RPR_76_89 2213 2337 58.5714
RPR_76_90 2231 2362 11.4286
RPR_76_91 2245 2247 54.2857
RPR_76_92 2245 2325 54.2857
RPR_76_93 2245 2391 10.047
RPR_76_94 2245 2282 11.875
RPR_76_95 2245 2322 11.875
RPR_76_96 2249 2300 58.5714
RPR_76_97 2251 2298 11.4286
RPR_76_98 2253 2299 58.5714
RPR_76_99 2271 2300 11.4286
RPR_76_100 2285 2294 11.4286
RPR_76_101 2287 2314 58.5714
RPR_76_102 2289 2322 58.5714
RPR_76_103 2291 2306 11.4286
RPR_76_104 2293 2297 58.5714
RPR_76_105 2311 2322 11.4286
RPR_76_106 2327 2260 58.5714
RPR_76_107 2329 2258 11.4286
RPR_76_108 2331 2259 58.5714
RPR_76_109 2333 2260 11.4286
RPR_76_110 2351 2254 11.4286
RPR_76_111 2365 2274 58.5714
RPR_76_112 2367 2282 58.5714
RPR_76_113 2369 2266 11.4286
RPR_76_114 2371 2257 58.5714
RPR_76_115 2373 2282 11.4286
RPR_76_116 2391 2405 54.2857
RPR_76_117 2391 2471 10.047
RPR_76_118 2391 2242 11.875
RPR_76_119 2407 2220 58.5714
RPR_76_120 2409 2218 11.4286
RPR_76_121 2411 2219 58.5714
RPR_76_122 2413 2220 11.4286
RPR_76_123 2431 2214 11.4286
RPR_76_124 2445 2234 58.5714
RPR_76_125 2447 2242 58.5714
RPR_76_126 2449 2226 11.4286
RPR_76_127 2451 2217 58.5714
RPR_76_128 2453 2242 11.4286
RPR_76_129 2471 2485 54.2857
RPR_76_130 2471 2551 30.6915
RPR_76_131 2471 2202 11.875
RPR_76_132 2487 2180 58.5714
RPR_76_133 2489 2178 11.4286
RPR_76_134 2491 2179 58.5714
RPR_76_135 2493 2180 11.4286
RPR_76_136 2511 2174 11.4286
RPR_76_137 2525 2194 58.5714
RPR_76_138 2527 2202 58.5714
RPR_76_139 2529 2186 11.4286
RPR_76_140 2531 2177 58.5714
RPR_76_141 2533 2202 11.4286
RPR_76_142 2551 2565 54.2857
RPR_76_143 2551 1710 10.047
RPR_76_144 2551 2162 11.875
RPR_76_145 2567 2140 58.5714
RPR_76_146 2569 2138 11.4286
RPR_76_147 2571 2139 58.5714
RPR_76_148 2573 2140 11.4286
RPR_76_149 2591 2134 11.4286
RPR_76_150 2966 2154 58.5714
RPR_76_151 1686 2162 58.5714
RPR_76_152 1688 2146 11.4286
RPR_76_153 1690 2137 58.5714
RPR_76_154 1692 2162 11.4286
RPR_76_155 1710 2967 54.2857
RPR_76_156 1710 1790 10.047
RPR_76_157 1710 2122 11.875
RPR_76_158 1726 2100 58.5714
RPR_76_159 1728 2098 11.4286
RPR_76_160 1730 2099 58.5714
RPR_76_161 1732 2100 11.4286
RPR_76_162 1750 2094 11.4286
RPR_76_163 2968 2114 58.5714
RPR_76_164 1766 2122 58.5714
RPR_76_165 1768 2106 11.4286
RPR_76_166 1770 2097 58.5714
RPR_76_167 1772 2122 11.4286
RPR_76_168 1790 2969 54.2857
RPR_76_169 1790 1870 10.047
RPR_76_170 1790 2082 11.875
RPR_76_171 1806 2060 58.5714
RPR_76_172 1808 2058 11.4286
RPR_76_173 1810 2059 58.5714
RPR_76_174 1812 2060 11.4286
RPR_76_175 1830 2054 11.4286
RPR_76_176 2970 2074 58.5714
RPR_76_177 1846 2082 58.5714
RPR_76_178 1848 2066 11.4286
RPR_76_179 1850 2057 58.5714
RPR_76_180 1852 2082 11.4286
RPR_76_181 1870 2971 54.2857
RPR_76_182 1870 1950 10.047
RPR_76_183 1870 2042 11.875
RPR_76_184 1886 2020 58.5714
RPR_76_185 1888 2018 11.4286
RPR_76_186 1890 2019 58.5714
RPR_76_187 1892 2020 11.4286
RPR_76_188 1910 2014 11.4286
RPR_76_189 2972 2034 58.5714
RPR_76_190 1926 2042 58.5714
RPR_76_191 1928 2026 11.4286
RPR_76_192 1930 2017 58.5714
RPR_76_193 1932 2042 11.4286
RPR_76_194 1950 2974 54.2857
RPR_76_195 1950 2975 54.2857
RPR_76_196 1950 2110 10.047
RPR_76_197 1950 1962 11.875
RPR_76_198 1950 2002 11.875
RPR_76_199 1966 1980 58.5714
RPR_76_200 1968 1978 11.4286
RPR_76_201 1970 1979 58.5714
RPR_76_202 1972 1980 11.4286
RPR_76_203 1990 1974 11.4286
RPR_76_204 2006 1994 58.5714
RPR_76_205 2008 2002 58.5714
RPR_76_206 2010 1986 11.4286
RPR_76_207 2012 1977 58.5714
RPR_76_208 2030 2002 11.4286
RPR_76_209 2046 1940 58.5714
RPR_76_210 2048 1938 11.4286
RPR_76_211 2050 1939 58.5714
RPR_76_212 2052 1940 11.4286
RPR_76_213 2070 1934 11.4286
RPR_76_214 2976 1954 58.5714
RPR_76_215 2086 1962 58.5714
RPR_76_216 2088 1946 11.4286
RPR_76_217 2090 1937 58.5714
RPR_76_218 2092 1962 11.4286
RPR_76_219 2110 2979 54.2857
RPR_76_220 2110 2190 10.047
RPR_76_221 2110 1922 11.875
RPR_76_222 2126 1900 58.5714
RPR_76_223 2128 1898 11.4286
RPR_76_224 2130 1899 58.5714
RPR_76_225 2132 1900 11.4286
RPR_76_226 2150 1894 11.4286
RPR_76_227 2980 1914 58.5714
RPR_76_228 2166 1922 58.5714
RPR_76_229 2168 1906 11.4286
RPR_76_230 2170 1897 58.5714
RPR_76_231 2172 1922 11.4286
RPR_76_232 2190 2981 54.2857
RPR_76_233 2190 2270 10.047
RPR_76_234 2190 1882 11.875
RPR_76_235 2206 1860 58.5714
RPR_76_236 2208 1858 11.4286
RPR_76_237 2210 1859 58.5714
RPR_76_238 2212 1860 11.4286
RPR_76_239 2230 1854 11.4286
RPR_76_240 2982 1874 58.5714
RPR_76_241 2246 1882 58.5714
RPR_76_242 2248 1866 11.4286
RPR_76_243 2250 1857 58.5714
RPR_76_244 2252 1882 11.4286
RPR_76_245 2270 2984 54.2857
RPR_76_246 2270 2985 10.047
RPR_76_247 2270 1842 11.875
RPR_76_248 2286 1820 58.5714
RPR_76_249 2288 1818 11.4286
RPR_76_250 2290 1819 58.5714
RPR_76_251 2292 1820 11.4286
RPR_76_252 2310 1814 11.4286
RPR_76_253 2326 1834 58.5714
RPR_76_254 2328 1842 58.5714
RPR_76_255 2330 1826 11.4286
RPR_76_256 2332 1817 58.5714
RPR_76_257 2350 1842 11.4286
RPR_76_258 2985 2366 54.2857
RPR_76_259 2985 2989 10.047
RPR_76_260 2985 1802 11.875
RPR_76_261 2368 1780 58.5714
RPR_76_262 2370 1778 11.4286
RPR_76_263 2372 1779 58.5714
RPR_76_264 2390 1780 11.4286
RPR_76_265 2988 1774 11.4286
RPR_76_266 2406 1794 58.5714
RPR_76_267 2408 1802 58.5714
RPR_76_268 2410 1786 11.4286
RPR_76_269 2412 1777 58.5714
RPR_76_270 2430 1802 11.4286
RPR_76_271 2989 2446 54.2857
RPR_76_272 2989 2991 10.047
RPR_76_273 2989 1762 11.875
RPR_76_274 2448 1740 58.5714
RPR_76_275 2450 1738 11.4286
RPR_76_276 2452 1739 58.5714
RPR_76_277 2470 1740 11.4286
RPR_76_278 2990 1734 11.4286
RPR_76_279 2486 1754 58.5714
RPR_76_280 2488 1762 58.5714
RPR_76_281 2490 1746 11.4286
RPR_76_282 2492 1737 58.5714
RPR_76_283 2510 1762 11.4286
RPR_76_284 2991 2526 54.2857
RPR_76_285 2991 1722 11.875
RPR_76_286 2528 1700 58.5714
RPR_76_287 2530 1700 42.3406
RPR_76_288 2530 2532 201.794
RPR_76_289 2532 1700 129.668
RPR_76_290 2550 1700 11.4286
RPR_76_291 2992 1694 11.4286
RPR_76_292 2566 1714 58.5714
RPR_76_293 2568 1722 58.5714
RPR_76_294 2570 1706 11.4286
RPR_76_295 2572 1697 58.5714
RPR_76_296 2590 1722 11.4286
RPR_76_297 2600 2580 12.5
RPR_76_298 2600 2595 14.6875
RPR_76_299 2600 2594 11.4286
RPR_76_300 2600 2574 11.4286
RPR_76_301 2602 2595 14.6875
RPR_76_302 2595 2577 11.4286
RPR_76_303 2595 2586 11.4286
RPR_76_304 2580 2581 14.6875
RPR_76_305 2581 2579 11.4286
RPR_76_306 2581 2578 11.4286
RPR_76_307 2560 2540 12.5
RPR_76_308 2560 2555 14.6875
RPR_76_309 2560 2554 11.4286
RPR_76_310 2560 2534 11.4286
RPR_76_311 2562 2555 14.6875
RPR_76_312 2555 2537 11.4286
RPR_76_313 2555 2546 11.4286
RPR_76_314 2540 2541 14.6875
RPR_76_315 2541 2539 11.4286
RPR_76_316 2541 2538 11.4286
RPR_76_317 2520 2500 12.5
RPR_76_318 2520 2515 14.6875
RPR_76_319 2520 2514 11.4286
RPR_76_320 2520 2494 11.4286
RPR_76_321 2522 2515 14.6875
RPR_76_322 2515 2497 11.4286
RPR_76_323 2515 2506 11.4286
RPR_76_324 2500 2501 14.6875
RPR_76_325 2501 2499 11.4286
RPR_76_326 2501 2498 11.4286
RPR_76_327 2480 2460 12.5
RPR_76_328 2480 2475 14.6875
RPR_76_329 2480 2474 11.4286
RPR_76_330 2480 2454 11.4286
RPR_76_331 2482 2475 14.6875
RPR_76_332 2475 2457 11.4286
RPR_76_333 2475 2466 11.4286
RPR_76_334 2460 2461 14.6875
RPR_76_335 2461 2459 11.4286
RPR_76_336 2461 2458 11.4286
RPR_76_337 2440 2420 12.5
RPR_76_338 2440 2435 14.6875
RPR_76_339 2440 2434 11.4286
RPR_76_340 2440 2414 11.4286
RPR_76_341 2442 2435 14.6875
RPR_76_342 2435 2417 11.4286
RPR_76_343 2435 2426 11.4286
RPR_76_344 2420 2421 14.6875
RPR_76_345 2421 2419 11.4286
RPR_76_346 2421 2418 11.4286
RPR_76_347 2400 2380 12.5
RPR_76_348 2400 2395 14.6875
RPR_76_349 2400 2394 11.4286
RPR_76_350 2400 2374 11.4286
RPR_76_351 2402 2395 14.6875
RPR_76_352 2395 2377 11.4286
RPR_76_353 2395 2386 11.4286
RPR_76_354 2380 2381 14.6875
RPR_76_355 2381 2379 11.4286
RPR_76_356 2381 2378 11.4286
RPR_76_357 2360 2340 12.5
RPR_76_358 2360 2355 14.6875
RPR_76_359 2360 2354 11.4286
RPR_76_360 2360 2334 11.4286
RPR_76_361 2362 2355 14.6875
RPR_76_362 2355 2337 11.4286
RPR_76_363 2355 2346 11.4286
RPR_76_364 2340 2341 14.6875
RPR_76_365 2341 2339 11.4286
RPR_76_366 2341 2338 11.4286
RPR_76_367 2320 2300 12.5
RPR_76_368 2320 2315 14.6875
RPR_76_369 2320 2314 11.4286
RPR_76_370 2320 2294 11.4286
RPR_76_371 2322 2315 14.6875
RPR_76_372 2315 2297 11.4286
RPR_76_373 2315 2306 11.4286
RPR_76_374 2300 2301 14.6875
RPR_76_375 2301 2299 11.4286
RPR_76_376 2301 2298 11.4286
RPR_76_377 2280 2260 12.5
RPR_76_378 2280 2275 14.6875
RPR_76_379 2280 2274 11.4286
RPR_76_380 2280 2254 11.4286
RPR_76_381 2282 2275 14.6875
RPR_76_382 2275 2257 11.4286
RPR_76_383 2275 2266 11.4286
RPR_76_384 2260 2261 14.6875
RPR_76_385 2261 2259 11.4286
RPR_76_386 2261 2258 11.4286
RPR_76_387 2240 2220 12.5
RPR_76_388 2240 2235 14.6875
RPR_76_389 2240 2234 11.4286
RPR_76_390 2240 2214 11.4286
RPR_76_391 2242 2235 14.6875
RPR_76_392 2235 2217 11.4286
RPR_76_393 2235 2226 11.4286
RPR_76_394 2220 2221 14.6875
RPR_76_395 2221 2219 11.4286
RPR_76_396 2221 2218 11.4286
RPR_76_397 2200 2180 12.5
RPR_76_398 2200 2195 14.6875
RPR_76_399 2200 2194 11.4286
RPR_76_400 2200 2174 11.4286
RPR_76_401 2202 2195 14.6875
RPR_76_402 2195 2177 11.4286
RPR_76_403 2195 2186 11.4286
RPR_76_404 2180 2181 14.6875
RPR_76_405 2181 2179 11.4286
RPR_76_406 2181 2178 11.4286
RPR_76_407 2160 2140 12.5
RPR_76_408 2160 2155 14.6875
RPR_76_409 2160 2154 11.4286
RPR_76_410 2160 2134 11.4286
RPR_76_411 2162 2155 14.6875
RPR_76_412 2155 2137 11.4286
RPR_76_413 2155 2146 11.4286
RPR_76_414 2140 2141 14.6875
RPR_76_415 2141 2139 11.4286
RPR_76_416 2141 2138 11.4286
RPR_76_417 2120 2100 12.5
RPR_76_418 2120 2115 14.6875
RPR_76_419 2120 2114 11.4286
RPR_76_420 2120 2094 11.4286
RPR_76_421 2122 2115 14.6875
RPR_76_422 2115 2097 11.4286
RPR_76_423 2115 2106 11.4286
RPR_76_424 2100 2101 14.6875
RPR_76_425 2101 2099 11.4286
RPR_76_426 2101 2098 11.4286
RPR_76_427 2080 2060 12.5
RPR_76_428 2080 2075 14.6875
RPR_76_429 2080 2074 11.4286
RPR_76_430 2080 2054 11.4286
RPR_76_431 2082 2075 14.6875
RPR_76_432 2075 2057 11.4286
RPR_76_433 2075 2066 11.4286
RPR_76_434 2060 2061 14.6875
RPR_76_435 2061 2059 11.4286
RPR_76_436 2061 2058 11.4286
RPR_76_437 2040 2020 12.5
RPR_76_438 2040 2035 14.6875
RPR_76_439 2040 2034 11.4286
RPR_76_440 2040 2014 11.4286
RPR_76_441 2042 2035 14.6875
RPR_76_442 2035 2017 11.4286
RPR_76_443 2035 2026 11.4286
RPR_76_444 2020 2021 14.6875
RPR_76_445 2021 2019 11.4286
RPR_76_446 2021 2018 11.4286
RPR_76_447 2000 1980 12.5
RPR_76_448 2000 1995 14.6875
RPR_76_449 2000 1994 11.4286
RPR_76_450 2000 1974 11.4286
RPR_76_451 2002 1995 14.6875
RPR_76_452 1995 1977 11.4286
RPR_76_453 1995 1986 11.4286
RPR_76_454 1980 1981 14.6875
RPR_76_455 1981 1979 11.4286
RPR_76_456 1981 1978 11.4286
RPR_76_457 1960 1940 12.5
RPR_76_458 1960 1955 14.6875
RPR_76_459 1960 1954 11.4286
RPR_76_460 1960 1934 11.4286
RPR_76_461 1962 1955 14.6875
RPR_76_462 1955 1937 11.4286
RPR_76_463 1955 1946 11.4286
RPR_76_464 1940 1941 14.6875
RPR_76_465 1941 1939 11.4286
RPR_76_466 1941 1938 11.4286
RPR_76_467 1920 1900 12.5
RPR_76_468 1920 1915 14.6875
RPR_76_469 1920 1914 11.4286
RPR_76_470 1920 1894 11.4286
RPR_76_471 1922 1915 14.6875
RPR_76_472 1915 1897 11.4286
RPR_76_473 1915 1906 11.4286
RPR_76_474 1900 1901 14.6875
RPR_76_475 1901 1899 11.4286
RPR_76_476 1901 1898 11.4286
RPR_76_477 1880 1860 12.5
RPR_76_478 1880 1875 14.6875
RPR_76_479 1880 1874 11.4286
RPR_76_480 1880 1854 11.4286
RPR_76_481 1882 1875 14.6875
RPR_76_482 1875 1857 11.4286
RPR_76_483 1875 1866 11.4286
RPR_76_484 1860 1861 14.6875
RPR_76_485 1861 1859 11.4286
RPR_76_486 1861 1858 11.4286
RPR_76_487 1840 1820 12.5
RPR_76_488 1840 1835 14.6875
RPR_76_489 1840 1834 11.4286
RPR_76_490 1840 1814 11.4286
RPR_76_491 1842 1835 14.6875
RPR_76_492 1835 1817 11.4286
RPR_76_493 1835 1826 11.4286
RPR_76_494 1820 1821 14.6875
RPR_76_495 1821 1819 11.4286
RPR_76_496 1821 1818 11.4286
RPR_76_497 1800 1780 12.5
RPR_76_498 1800 1795 14.6875
RPR_76_499 1800 1794 11.4286
RPR_76_500 1800 1774 11.4286
RPR_76_501 1802 1795 14.6875
RPR_76_502 1795 1777 11.4286
RPR_76_503 1795 1786 11.4286
RPR_76_504 1780 1781 14.6875
RPR_76_505 1781 1779 11.4286
RPR_76_506 1781 1778 11.4286
RPR_76_507 1760 1740 12.5
RPR_76_508 1760 1755 14.6875
RPR_76_509 1760 1754 11.4286
RPR_76_510 1760 1734 11.4286
RPR_76_511 1762 1755 14.6875
RPR_76_512 1755 1737 11.4286
RPR_76_513 1755 1746 11.4286
RPR_76_514 1740 1741 14.6875
RPR_76_515 1741 1739 11.4286
RPR_76_516 1741 1738 11.4286
RPR_76_517 1720 1700 12.5
RPR_76_518 1720 1715 14.6875
RPR_76_519 1720 1714 11.4286
RPR_76_520 1720 1694 11.4286
RPR_76_521 1722 1715 14.6875
RPR_76_522 1715 1697 11.4286
RPR_76_523 1715 1706 11.4286
CPR_76_524 1685 GND 2.64848e-014
CPR_76_525 1765 GND 2.64848e-014
CPR_76_526 1845 GND 2.64848e-014
CPR_76_527 1925 GND 2.64849e-014
CPR_76_528 2005 GND 2.64848e-014
CPR_76_529 2085 GND 2.64848e-014
CPR_76_530 2165 GND 2.64939e-014
CPR_76_531 2245 GND 5.30388e-014
CPR_76_532 2391 GND 2.64848e-014
CPR_76_533 2471 GND 5.37555e-014
CPR_76_534 2551 GND 5.37555e-014
CPR_76_535 1710 GND 2.64848e-014
CPR_76_536 1790 GND 2.64848e-014
CPR_76_537 1870 GND 2.64939e-014
CPR_76_538 1950 GND 5.30388e-014
CPR_76_539 2110 GND 2.64848e-014
CPR_76_540 2190 GND 2.64848e-014
CPR_76_541 2270 GND 2.64848e-014
CPR_76_542 2985 GND 2.64848e-014
CPR_76_543 2989 GND 2.64849e-014
CPR_76_544 2991 GND 2.64939e-014
CPR_76_545 2530 GND 1.20831e-016
CPR_76_546 2532 GND 1.42853e-016
CPR_76_547 2600 GND 1.52116e-016
CPR_76_548 2602 GND 1.71229e-016
CPR_76_549 2580 GND 1.57996e-016
CPR_76_550 2579 GND 1.25147e-016
CPR_76_551 2560 GND 1.52116e-016
CPR_76_552 2562 GND 1.71228e-016
CPR_76_553 2540 GND 1.5793e-016
CPR_76_554 2539 GND 1.2519e-016
CPR_76_555 2520 GND 1.52116e-016
CPR_76_556 2522 GND 1.72197e-016
CPR_76_557 2500 GND 1.56958e-016
CPR_76_558 2499 GND 1.25185e-016
CPR_76_559 2480 GND 1.52116e-016
CPR_76_560 2482 GND 1.72197e-016
CPR_76_561 2460 GND 1.56959e-016
CPR_76_562 2459 GND 1.25152e-016
CPR_76_563 2440 GND 1.52116e-016
CPR_76_564 2442 GND 1.7197e-016
CPR_76_565 2420 GND 1.57709e-016
CPR_76_566 2419 GND 1.25148e-016
CPR_76_567 2400 GND 1.52116e-016
CPR_76_568 2402 GND 1.71224e-016
CPR_76_569 2380 GND 1.5793e-016
CPR_76_570 2379 GND 1.25201e-016
CPR_76_571 2360 GND 1.52116e-016
CPR_76_572 2362 GND 1.71223e-016
CPR_76_573 2340 GND 1.57706e-016
CPR_76_574 2339 GND 1.25153e-016
CPR_76_575 2320 GND 1.52116e-016
CPR_76_576 2322 GND 1.71975e-016
CPR_76_577 2300 GND 1.56957e-016
CPR_76_578 2299 GND 1.25148e-016
CPR_76_579 2280 GND 1.52116e-016
CPR_76_580 2282 GND 1.72197e-016
CPR_76_581 2260 GND 1.56959e-016
CPR_76_582 2259 GND 1.25152e-016
CPR_76_583 2240 GND 1.52116e-016
CPR_76_584 2242 GND 1.7197e-016
CPR_76_585 2220 GND 1.57709e-016
CPR_76_586 2219 GND 1.25148e-016
CPR_76_587 2200 GND 1.52116e-016
CPR_76_588 2202 GND 1.71224e-016
CPR_76_589 2180 GND 1.5793e-016
CPR_76_590 2179 GND 1.25201e-016
CPR_76_591 2160 GND 1.52116e-016
CPR_76_592 2162 GND 1.72197e-016
CPR_76_593 2140 GND 1.56959e-016
CPR_76_594 2139 GND 1.25152e-016
CPR_76_595 2120 GND 1.52116e-016
CPR_76_596 2122 GND 1.7197e-016
CPR_76_597 2100 GND 1.57709e-016
CPR_76_598 2099 GND 1.25148e-016
CPR_76_599 2080 GND 1.52116e-016
CPR_76_600 2082 GND 1.71223e-016
CPR_76_601 2060 GND 1.5793e-016
CPR_76_602 2059 GND 1.25201e-016
CPR_76_603 2040 GND 1.52116e-016
CPR_76_604 2042 GND 1.71224e-016
CPR_76_605 2020 GND 1.57705e-016
CPR_76_606 2019 GND 1.25147e-016
CPR_76_607 2000 GND 1.52116e-016
CPR_76_608 2002 GND 1.71975e-016
CPR_76_609 1980 GND 1.56959e-016
CPR_76_610 1979 GND 1.25152e-016
CPR_76_611 1960 GND 1.52116e-016
CPR_76_612 1962 GND 1.72197e-016
CPR_76_613 1940 GND 1.56957e-016
CPR_76_614 1939 GND 1.25153e-016
CPR_76_615 1920 GND 1.52116e-016
CPR_76_616 1922 GND 1.7197e-016
CPR_76_617 1900 GND 1.57709e-016
CPR_76_618 1899 GND 1.25148e-016
CPR_76_619 1880 GND 1.52116e-016
CPR_76_620 1882 GND 1.71223e-016
CPR_76_621 1860 GND 1.5793e-016
CPR_76_622 1859 GND 1.25201e-016
CPR_76_623 1840 GND 1.52116e-016
CPR_76_624 1842 GND 1.71224e-016
CPR_76_625 1820 GND 1.57705e-016
CPR_76_626 1819 GND 1.25147e-016
CPR_76_627 1800 GND 1.52116e-016
CPR_76_628 1802 GND 1.71975e-016
CPR_76_629 1780 GND 1.56959e-016
CPR_76_630 1779 GND 1.25152e-016
CPR_76_631 1760 GND 1.52116e-016
CPR_76_632 1762 GND 1.72197e-016
CPR_76_633 1740 GND 1.56957e-016
CPR_76_634 1739 GND 1.25153e-016
CPR_76_635 1720 GND 1.52116e-016
CPR_76_636 1722 GND 1.7197e-016
CPR_76_637 1700 GND 2.76164e-016
rp2892 906 900 14.6875
rp1803 2940 2939 10.047
rp1743 2966 2965 10.047
rp1683 2995 2992 10.047
m0 3023 5 vdd vdd p l=0.54 w=3 ad=2.7 pd=7.8 as=1.5 ps=4
m1 vdd 7 3023 vdd p l=0.54 w=3 ad=1.5 pd=4 as=3 ps=8
m2 3024 9 vdd vdd p l=0.54 w=3 ad=1.5 pd=4 as=3 ps=8
m3 vdd 11 3024 vdd p l=0.54 w=3 ad=1.5 pd=4 as=3 ps=8
m4 3025 13 vdd vdd p l=0.54 w=3 ad=1.5 pd=4 as=3 ps=8
m5 vdd 31 3025 vdd p l=0.54 w=3 ad=1.5 pd=4 as=2.7 ps=7.8
m6 3051 45 vdd vdd p l=0.54 w=3 ad=2.7 pd=7.8 as=1.5 ps=4
m7 vdd 47 3051 vdd p l=0.54 w=3 ad=1.5 pd=4 as=3 ps=8
m8 3052 49 vdd vdd p l=0.54 w=3 ad=1.5 pd=4 as=3 ps=8
m9 vdd 51 3052 vdd p l=0.54 w=3 ad=1.5 pd=4 as=3 ps=8
m10 3053 53 vdd vdd p l=0.54 w=3 ad=1.5 pd=4 as=3 ps=8
m11 vdd 71 3053 vdd p l=0.54 w=3 ad=1.5 pd=4 as=2.7 ps=7.8
m12 3079 85 vdd vdd p l=0.54 w=3 ad=2.7 pd=7.8 as=1.5 ps=4
m13 vdd 87 3079 vdd p l=0.54 w=3 ad=1.5 pd=4 as=3 ps=8
m14 3080 89 vdd vdd p l=0.54 w=3 ad=1.5 pd=4 as=3 ps=8
m15 vdd 91 3080 vdd p l=0.54 w=3 ad=1.5 pd=4 as=3 ps=8
m16 3081 93 vdd vdd p l=0.54 w=3 ad=1.5 pd=4 as=3 ps=8
m17 vdd 111 3081 vdd p l=0.54 w=3 ad=1.5 pd=4 as=2.7 ps=7.8
m18 3107 125 vdd vdd p l=0.54 w=3 ad=2.7 pd=7.8 as=1.5 ps=4
m19 vdd 127 3107 vdd p l=0.54 w=3 ad=1.5 pd=4 as=3 ps=8
m20 3108 129 vdd vdd p l=0.54 w=3 ad=1.5 pd=4 as=3 ps=8
m21 vdd 131 3108 vdd p l=0.54 w=3 ad=1.5 pd=4 as=3 ps=8
m22 3109 133 vdd vdd p l=0.54 w=3 ad=1.5 pd=4 as=3 ps=8
m23 vdd 151 3109 vdd p l=0.54 w=3 ad=1.5 pd=4 as=2.7 ps=7.8
m24 3135 165 vdd vdd p l=0.54 w=3 ad=2.7 pd=7.8 as=1.5 ps=4
m25 vdd 167 3135 vdd p l=0.54 w=3 ad=1.5 pd=4 as=3 ps=8
m26 3136 169 vdd vdd p l=0.54 w=3 ad=1.5 pd=4 as=3 ps=8
m27 vdd 171 3136 vdd p l=0.54 w=3 ad=1.5 pd=4 as=3 ps=8
m28 3137 173 vdd vdd p l=0.54 w=3 ad=1.5 pd=4 as=3 ps=8
m29 vdd 191 3137 vdd p l=0.54 w=3 ad=1.5 pd=4 as=2.7 ps=7.8
m30 2999 3149 vdd vdd p l=0.54 w=3 ad=1.5 pd=7 as=1.5 ps=4
m31 vdd 3151 2999 vdd p l=0.54 w=3 ad=1.5 pd=4 as=3 ps=8
m32 3000 3153 vdd vdd p l=0.54 w=3 ad=1.5 pd=4 as=3 ps=8
m33 vdd 3155 3000 vdd p l=0.54 w=3 ad=1.5 pd=4 as=1.5 ps=7
m34 3195 205 vdd vdd p l=0.54 w=3 ad=2.7 pd=7.8 as=1.5 ps=4
m35 vdd 207 3195 vdd p l=0.54 w=3 ad=1.5 pd=4 as=3 ps=8
m36 3196 209 vdd vdd p l=0.54 w=3 ad=1.5 pd=4 as=3 ps=8
m37 vdd 211 3196 vdd p l=0.54 w=3 ad=1.5 pd=4 as=3 ps=8
m38 3197 213 vdd vdd p l=0.54 w=3 ad=1.5 pd=4 as=3 ps=8
m39 vdd 231 3197 vdd p l=0.54 w=3 ad=1.5 pd=4 as=2.7 ps=7.8
m40 3223 245 vdd vdd p l=0.54 w=3 ad=2.7 pd=7.8 as=1.5 ps=4
m41 vdd 247 3223 vdd p l=0.54 w=3 ad=1.5 pd=4 as=3 ps=8
m42 3224 249 vdd vdd p l=0.54 w=3 ad=1.5 pd=4 as=3 ps=8
m43 vdd 251 3224 vdd p l=0.54 w=3 ad=1.5 pd=4 as=3 ps=8
m44 3225 253 vdd vdd p l=0.54 w=3 ad=1.5 pd=4 as=3 ps=8
m45 vdd 271 3225 vdd p l=0.54 w=3 ad=1.5 pd=4 as=2.7 ps=7.8
m46 3251 285 vdd vdd p l=0.54 w=3 ad=2.7 pd=7.8 as=1.5 ps=4
m47 vdd 287 3251 vdd p l=0.54 w=3 ad=1.5 pd=4 as=3 ps=8
m48 3252 289 vdd vdd p l=0.54 w=3 ad=1.5 pd=4 as=3 ps=8
m49 vdd 291 3252 vdd p l=0.54 w=3 ad=1.5 pd=4 as=3 ps=8
m50 3253 293 vdd vdd p l=0.54 w=3 ad=1.5 pd=4 as=3 ps=8
m51 vdd 311 3253 vdd p l=0.54 w=3 ad=1.5 pd=4 as=2.7 ps=7.8
m52 3279 325 vdd vdd p l=0.54 w=3 ad=2.7 pd=7.8 as=1.5 ps=4
m53 vdd 327 3279 vdd p l=0.54 w=3 ad=1.5 pd=4 as=3 ps=8
m54 3280 329 vdd vdd p l=0.54 w=3 ad=1.5 pd=4 as=3 ps=8
m55 vdd 331 3280 vdd p l=0.54 w=3 ad=1.5 pd=4 as=3 ps=8
m56 3281 333 vdd vdd p l=0.54 w=3 ad=1.5 pd=4 as=3 ps=8
m57 vdd 351 3281 vdd p l=0.54 w=3 ad=1.5 pd=4 as=2.7 ps=7.8
m58 3307 365 vdd vdd p l=0.54 w=3 ad=2.7 pd=7.8 as=1.5 ps=4
m59 vdd 367 3307 vdd p l=0.54 w=3 ad=1.5 pd=4 as=3 ps=8
m60 3308 369 vdd vdd p l=0.54 w=3 ad=1.5 pd=4 as=3 ps=8
m61 vdd 371 3308 vdd p l=0.54 w=3 ad=1.5 pd=4 as=3 ps=8
m62 3309 373 vdd vdd p l=0.54 w=3 ad=1.5 pd=4 as=3 ps=8
m63 vdd 391 3309 vdd p l=0.54 w=3 ad=1.5 pd=4 as=2.7 ps=7.8
m64 3335 405 vdd vdd p l=0.54 w=3 ad=2.7 pd=7.8 as=1.5 ps=4
m65 vdd 407 3335 vdd p l=0.54 w=3 ad=1.5 pd=4 as=3 ps=8
m66 3336 409 vdd vdd p l=0.54 w=3 ad=1.5 pd=4 as=3 ps=8
m67 vdd 411 3336 vdd p l=0.54 w=3 ad=1.5 pd=4 as=3 ps=8
m68 3337 413 vdd vdd p l=0.54 w=3 ad=1.5 pd=4 as=3 ps=8
m69 vdd 431 3337 vdd p l=0.54 w=3 ad=1.5 pd=4 as=2.7 ps=7.8
m70 3363 445 vdd vdd p l=0.54 w=3 ad=2.7 pd=7.8 as=1.5 ps=4
m71 vdd 447 3363 vdd p l=0.54 w=3 ad=1.5 pd=4 as=3 ps=8
m72 3364 449 vdd vdd p l=0.54 w=3 ad=1.5 pd=4 as=3 ps=8
m73 vdd 451 3364 vdd p l=0.54 w=3 ad=1.5 pd=4 as=3 ps=8
m74 3365 453 vdd vdd p l=0.54 w=3 ad=1.5 pd=4 as=3 ps=8
m75 vdd 471 3365 vdd p l=0.54 w=3 ad=1.5 pd=4 as=2.7 ps=7.8
m76 3391 485 vdd vdd p l=0.54 w=3 ad=2.7 pd=7.8 as=1.5 ps=4
m77 vdd 487 3391 vdd p l=0.54 w=3 ad=1.5 pd=4 as=3 ps=8
m78 3392 489 vdd vdd p l=0.54 w=3 ad=1.5 pd=4 as=3 ps=8
m79 vdd 491 3392 vdd p l=0.54 w=3 ad=1.5 pd=4 as=3 ps=8
m80 3393 493 vdd vdd p l=0.54 w=3 ad=1.5 pd=4 as=3 ps=8
m81 vdd 511 3393 vdd p l=0.54 w=3 ad=1.5 pd=4 as=2.7 ps=7.8
m82 3419 525 vdd vdd p l=0.54 w=3 ad=2.7 pd=7.8 as=1.5 ps=4
m83 vdd 527 3419 vdd p l=0.54 w=3 ad=1.5 pd=4 as=3 ps=8
m84 3420 529 vdd vdd p l=0.54 w=3 ad=1.5 pd=4 as=3 ps=8
m85 vdd 531 3420 vdd p l=0.54 w=3 ad=1.5 pd=4 as=3 ps=8
m86 3421 533 vdd vdd p l=0.54 w=3 ad=1.5 pd=4 as=3 ps=8
m87 vdd 551 3421 vdd p l=0.54 w=3 ad=1.5 pd=4 as=2.7 ps=7.8
m88 3447 565 vdd vdd p l=0.54 w=3 ad=2.7 pd=7.8 as=1.5 ps=4
m89 vdd 567 3447 vdd p l=0.54 w=3 ad=1.5 pd=4 as=3 ps=8
m90 3448 569 vdd vdd p l=0.54 w=3 ad=1.5 pd=4 as=3 ps=8
m91 vdd 571 3448 vdd p l=0.54 w=3 ad=1.5 pd=4 as=3 ps=8
m92 3449 573 vdd vdd p l=0.54 w=3 ad=1.5 pd=4 as=3 ps=8
m93 vdd 591 3449 vdd p l=0.54 w=3 ad=1.5 pd=4 as=2.7 ps=7.8
m94 3475 605 vdd vdd p l=0.54 w=3 ad=2.7 pd=7.8 as=1.5 ps=4
m95 vdd 607 3475 vdd p l=0.54 w=3 ad=1.5 pd=4 as=3 ps=8
m96 3476 609 vdd vdd p l=0.54 w=3 ad=1.5 pd=4 as=3 ps=8
m97 vdd 611 3476 vdd p l=0.54 w=3 ad=1.5 pd=4 as=3 ps=8
m98 3477 613 vdd vdd p l=0.54 w=3 ad=1.5 pd=4 as=3 ps=8
m99 vdd 631 3477 vdd p l=0.54 w=3 ad=1.5 pd=4 as=2.7 ps=7.8
m100 3505 645 vdd vdd p l=0.54 w=3 ad=2.7 pd=7.8 as=1.5 ps=4
m101 vdd 647 3505 vdd p l=0.54 w=3 ad=1.5 pd=4 as=3 ps=8
m102 3506 649 vdd vdd p l=0.54 w=3 ad=1.5 pd=4 as=3 ps=8
m103 vdd 651 3506 vdd p l=0.54 w=3 ad=1.5 pd=4 as=3 ps=8
m104 3507 653 vdd vdd p l=0.54 w=3 ad=1.5 pd=4 as=3 ps=8
m105 vdd 671 3507 vdd p l=0.54 w=3 ad=1.5 pd=4 as=2.7 ps=7.8
m106 3533 685 vdd vdd p l=0.54 w=3 ad=2.7 pd=7.8 as=1.5 ps=4
m107 vdd 687 3533 vdd p l=0.54 w=3 ad=1.5 pd=4 as=3 ps=8
m108 3534 689 vdd vdd p l=0.54 w=3 ad=1.5 pd=4 as=3 ps=8
m109 vdd 691 3534 vdd p l=0.54 w=3 ad=1.5 pd=4 as=3 ps=8
m110 3535 693 vdd vdd p l=0.54 w=3 ad=1.5 pd=4 as=3 ps=8
m111 vdd 711 3535 vdd p l=0.54 w=3 ad=1.5 pd=4 as=2.7 ps=7.8
m112 3561 725 vdd vdd p l=0.54 w=3 ad=2.7 pd=7.8 as=1.5 ps=4
m113 vdd 727 3561 vdd p l=0.54 w=3 ad=1.5 pd=4 as=3 ps=8
m114 3562 729 vdd vdd p l=0.54 w=3 ad=1.5 pd=4 as=3 ps=8
m115 vdd 731 3562 vdd p l=0.54 w=3 ad=1.5 pd=4 as=3 ps=8
m116 3563 733 vdd vdd p l=0.54 w=3 ad=1.5 pd=4 as=3 ps=8
m117 vdd 751 3563 vdd p l=0.54 w=3 ad=1.5 pd=4 as=2.7 ps=7.8
m118 3589 765 vdd vdd p l=0.54 w=3 ad=2.7 pd=7.8 as=1.5 ps=4
m119 vdd 767 3589 vdd p l=0.54 w=3 ad=1.5 pd=4 as=3 ps=8
m120 3590 769 vdd vdd p l=0.54 w=3 ad=1.5 pd=4 as=3 ps=8
m121 vdd 771 3590 vdd p l=0.54 w=3 ad=1.5 pd=4 as=3 ps=8
m122 3591 773 vdd vdd p l=0.54 w=3 ad=1.5 pd=4 as=3 ps=8
m123 vdd 791 3591 vdd p l=0.54 w=3 ad=1.5 pd=4 as=2.7 ps=7.8
m124 3617 805 vdd vdd p l=0.54 w=3 ad=2.7 pd=7.8 as=1.5 ps=4
m125 vdd 807 3617 vdd p l=0.54 w=3 ad=1.5 pd=4 as=3 ps=8
m126 3618 809 vdd vdd p l=0.54 w=3 ad=1.5 pd=4 as=3 ps=8
m127 vdd 811 3618 vdd p l=0.54 w=3 ad=1.5 pd=4 as=3 ps=8
m128 3619 813 vdd vdd p l=0.54 w=3 ad=1.5 pd=4 as=3 ps=8
m129 vdd 831 3619 vdd p l=0.54 w=3 ad=1.5 pd=4 as=2.7 ps=7.8
m130 3645 845 vdd vdd p l=0.54 w=3 ad=2.7 pd=7.8 as=1.5 ps=4
m131 vdd 847 3645 vdd p l=0.54 w=3 ad=1.5 pd=4 as=3 ps=8
m132 3646 849 vdd vdd p l=0.54 w=3 ad=1.5 pd=4 as=3 ps=8
m133 vdd 851 3646 vdd p l=0.54 w=3 ad=1.5 pd=4 as=3 ps=8
m134 3647 853 vdd vdd p l=0.54 w=3 ad=1.5 pd=4 as=3 ps=8
m135 vdd 871 3647 vdd p l=0.54 w=3 ad=1.5 pd=4 as=2.7 ps=7.8
m136 3673 885 vdd vdd p l=0.54 w=3 ad=2.7 pd=7.8 as=1.5 ps=4
m137 vdd 887 3673 vdd p l=0.54 w=3 ad=1.5 pd=4 as=3 ps=8
m138 3674 889 vdd vdd p l=0.54 w=3 ad=1.5 pd=4 as=3 ps=8
m139 vdd 891 3674 vdd p l=0.54 w=3 ad=1.5 pd=4 as=3 ps=8
m140 3675 893 vdd vdd p l=0.54 w=3 ad=1.5 pd=4 as=3 ps=8
m141 vdd 911 3675 vdd p l=0.54 w=3 ad=1.5 pd=4 as=2.7 ps=7.8
m142 3701 925 vdd vdd p l=0.54 w=3 ad=2.7 pd=7.8 as=1.5 ps=4
m143 vdd 927 3701 vdd p l=0.54 w=3 ad=1.5 pd=4 as=3 ps=8
m144 3702 929 vdd vdd p l=0.54 w=3 ad=1.5 pd=4 as=3 ps=8
m145 vdd 931 3702 vdd p l=0.54 w=3 ad=1.5 pd=4 as=3 ps=8
m146 3703 933 vdd vdd p l=0.54 w=3 ad=1.5 pd=4 as=3 ps=8
m147 vdd 951 3703 vdd p l=0.54 w=3 ad=1.5 pd=4 as=2.7 ps=7.8
m148 3729 965 vdd vdd p l=0.54 w=3 ad=2.7 pd=7.8 as=1.5 ps=4
m149 vdd 967 3729 vdd p l=0.54 w=3 ad=1.5 pd=4 as=3 ps=8
m150 3730 969 vdd vdd p l=0.54 w=3 ad=1.5 pd=4 as=3 ps=8
m151 vdd 971 3730 vdd p l=0.54 w=3 ad=1.5 pd=4 as=3 ps=8
m152 3731 973 vdd vdd p l=0.54 w=3 ad=1.5 pd=4 as=3 ps=8
m153 vdd 991 3731 vdd p l=0.54 w=3 ad=1.5 pd=4 as=2.7 ps=7.8
m154 3757 1005 vdd vdd p l=0.54 w=3 ad=2.7 pd=7.8 as=1.5 ps=4
m155 vdd 1007 3757 vdd p l=0.54 w=3 ad=1.5 pd=4 as=3 ps=8
m156 3758 1009 vdd vdd p l=0.54 w=3 ad=1.5 pd=4 as=3 ps=8
m157 vdd 1011 3758 vdd p l=0.54 w=3 ad=1.5 pd=4 as=3 ps=8
m158 3759 1013 vdd vdd p l=0.54 w=3 ad=1.5 pd=4 as=3 ps=8
m159 vdd 1031 3759 vdd p l=0.54 w=3 ad=1.5 pd=4 as=2.7 ps=7.8
m160 3785 1045 vdd vdd p l=0.54 w=3 ad=2.7 pd=7.8 as=1.5 ps=4
m161 vdd 1047 3785 vdd p l=0.54 w=3 ad=1.5 pd=4 as=3 ps=8
m162 3786 1049 vdd vdd p l=0.54 w=3 ad=1.5 pd=4 as=3 ps=8
m163 vdd 1051 3786 vdd p l=0.54 w=3 ad=1.5 pd=4 as=3 ps=8
m164 3787 1053 vdd vdd p l=0.54 w=3 ad=1.5 pd=4 as=3 ps=8
m165 vdd 1071 3787 vdd p l=0.54 w=3 ad=1.5 pd=4 as=2.7 ps=7.8
m166 3813 1085 vdd vdd p l=0.54 w=3 ad=2.7 pd=7.8 as=1.5 ps=4
m167 vdd 1087 3813 vdd p l=0.54 w=3 ad=1.5 pd=4 as=3 ps=8
m168 3814 1089 vdd vdd p l=0.54 w=3 ad=1.5 pd=4 as=3 ps=8
m169 vdd 1091 3814 vdd p l=0.54 w=3 ad=1.5 pd=4 as=3 ps=8
m170 3815 1093 vdd vdd p l=0.54 w=3 ad=1.5 pd=4 as=3 ps=8
m171 vdd 1111 3815 vdd p l=0.54 w=3 ad=1.5 pd=4 as=2.7 ps=7.8
m172 3842 1125 vdd vdd p l=0.54 w=3 ad=2.7 pd=7.8 as=1.5 ps=4
m173 vdd 1127 3842 vdd p l=0.54 w=3 ad=1.5 pd=4 as=3 ps=8
m174 3843 1129 vdd vdd p l=0.54 w=3 ad=1.5 pd=4 as=3 ps=8
m175 vdd 1131 3843 vdd p l=0.54 w=3 ad=1.5 pd=4 as=3 ps=8
m176 3844 1133 vdd vdd p l=0.54 w=3 ad=1.5 pd=4 as=3 ps=8
m177 vdd 1151 3844 vdd p l=0.54 w=3 ad=1.5 pd=4 as=2.7 ps=7.8
m178 3870 1165 vdd vdd p l=0.54 w=3 ad=2.7 pd=7.8 as=1.5 ps=4
m179 vdd 1167 3870 vdd p l=0.54 w=3 ad=1.5 pd=4 as=3 ps=8
m180 3871 1169 vdd vdd p l=0.54 w=3 ad=1.5 pd=4 as=3 ps=8
m181 vdd 1171 3871 vdd p l=0.54 w=3 ad=1.5 pd=4 as=3 ps=8
m182 3872 1173 vdd vdd p l=0.54 w=3 ad=1.5 pd=4 as=3 ps=8
m183 vdd 1191 3872 vdd p l=0.54 w=3 ad=1.5 pd=4 as=2.7 ps=7.8
m184 3898 1205 vdd vdd p l=0.54 w=3 ad=2.7 pd=7.8 as=1.5 ps=4
m185 vdd 1207 3898 vdd p l=0.54 w=3 ad=1.5 pd=4 as=3 ps=8
m186 3899 1209 vdd vdd p l=0.54 w=3 ad=1.5 pd=4 as=3 ps=8
m187 vdd 1211 3899 vdd p l=0.54 w=3 ad=1.5 pd=4 as=3 ps=8
m188 3900 1213 vdd vdd p l=0.54 w=3 ad=1.5 pd=4 as=3 ps=8
m189 vdd 1231 3900 vdd p l=0.54 w=3 ad=1.5 pd=4 as=2.7 ps=7.8
m190 3926 1245 vdd vdd p l=0.54 w=3 ad=2.7 pd=7.8 as=1.5 ps=4
m191 vdd 1247 3926 vdd p l=0.54 w=3 ad=1.5 pd=4 as=3 ps=8
m192 3927 1249 vdd vdd p l=0.54 w=3 ad=1.5 pd=4 as=3 ps=8
m193 vdd 1251 3927 vdd p l=0.54 w=3 ad=1.5 pd=4 as=3 ps=8
m194 3928 1253 vdd vdd p l=0.54 w=3 ad=1.5 pd=4 as=3 ps=8
m195 vdd 1271 3928 vdd p l=0.54 w=3 ad=1.5 pd=4 as=2.7 ps=7.8
m196 3956 1285 vdd vdd p l=0.54 w=3 ad=2.7 pd=7.8 as=1.5 ps=4
m197 vdd 1287 3956 vdd p l=0.54 w=3 ad=1.5 pd=4 as=3 ps=8
m198 3957 1289 vdd vdd p l=0.54 w=3 ad=1.5 pd=4 as=3 ps=8
m199 vdd 1291 3957 vdd p l=0.54 w=3 ad=1.5 pd=4 as=3 ps=8
m200 3958 1293 vdd vdd p l=0.54 w=3 ad=1.5 pd=4 as=3 ps=8
m201 vdd 1311 3958 vdd p l=0.54 w=3 ad=1.5 pd=4 as=2.7 ps=7.8
m202 3984 1325 vdd vdd p l=0.54 w=3 ad=2.7 pd=7.8 as=1.5 ps=4
m203 vdd 1327 3984 vdd p l=0.54 w=3 ad=1.5 pd=4 as=3 ps=8
m204 3985 1329 vdd vdd p l=0.54 w=3 ad=1.5 pd=4 as=3 ps=8
m205 vdd 1331 3985 vdd p l=0.54 w=3 ad=1.5 pd=4 as=3 ps=8
m206 3986 1333 vdd vdd p l=0.54 w=3 ad=1.5 pd=4 as=3 ps=8
m207 vdd 1351 3986 vdd p l=0.54 w=3 ad=1.5 pd=4 as=2.7 ps=7.8
m208 4012 1365 vdd vdd p l=0.54 w=3 ad=2.7 pd=7.8 as=1.5 ps=4
m209 vdd 1367 4012 vdd p l=0.54 w=3 ad=1.5 pd=4 as=3 ps=8
m210 4013 1369 vdd vdd p l=0.54 w=3 ad=1.5 pd=4 as=3 ps=8
m211 vdd 1371 4013 vdd p l=0.54 w=3 ad=1.5 pd=4 as=3 ps=8
m212 4014 1373 vdd vdd p l=0.54 w=3 ad=1.5 pd=4 as=3 ps=8
m213 vdd 1391 4014 vdd p l=0.54 w=3 ad=1.5 pd=4 as=2.7 ps=7.8
m214 4040 1405 vdd vdd p l=0.54 w=3 ad=2.7 pd=7.8 as=1.5 ps=4
m215 vdd 1407 4040 vdd p l=0.54 w=3 ad=1.5 pd=4 as=3 ps=8
m216 4041 1409 vdd vdd p l=0.54 w=3 ad=1.5 pd=4 as=3 ps=8
m217 vdd 1411 4041 vdd p l=0.54 w=3 ad=1.5 pd=4 as=3 ps=8
m218 4042 1413 vdd vdd p l=0.54 w=3 ad=1.5 pd=4 as=3 ps=8
m219 vdd 1431 4042 vdd p l=0.54 w=3 ad=1.5 pd=4 as=2.7 ps=7.8
m220 4068 1445 vdd vdd p l=0.54 w=3 ad=2.7 pd=7.8 as=1.5 ps=4
m221 vdd 1447 4068 vdd p l=0.54 w=3 ad=1.5 pd=4 as=3 ps=8
m222 4069 1449 vdd vdd p l=0.54 w=3 ad=1.5 pd=4 as=3 ps=8
m223 vdd 1451 4069 vdd p l=0.54 w=3 ad=1.5 pd=4 as=3 ps=8
m224 4070 1453 vdd vdd p l=0.54 w=3 ad=1.5 pd=4 as=3 ps=8
m225 vdd 1471 4070 vdd p l=0.54 w=3 ad=1.5 pd=4 as=2.7 ps=7.8
m226 4096 1485 vdd vdd p l=0.54 w=3 ad=2.7 pd=7.8 as=1.5 ps=4
m227 vdd 1487 4096 vdd p l=0.54 w=3 ad=1.5 pd=4 as=3 ps=8
m228 4097 1489 vdd vdd p l=0.54 w=3 ad=1.5 pd=4 as=3 ps=8
m229 vdd 1491 4097 vdd p l=0.54 w=3 ad=1.5 pd=4 as=3 ps=8
m230 4098 1493 vdd vdd p l=0.54 w=3 ad=1.5 pd=4 as=3 ps=8
m231 vdd 1511 4098 vdd p l=0.54 w=3 ad=1.5 pd=4 as=2.7 ps=7.8
m232 4124 1525 vdd vdd p l=0.54 w=3 ad=2.7 pd=7.8 as=1.5 ps=4
m233 vdd 1527 4124 vdd p l=0.54 w=3 ad=1.5 pd=4 as=3 ps=8
m234 4125 1529 vdd vdd p l=0.54 w=3 ad=1.5 pd=4 as=3 ps=8
m235 vdd 1531 4125 vdd p l=0.54 w=3 ad=1.5 pd=4 as=3 ps=8
m236 4126 1533 vdd vdd p l=0.54 w=3 ad=1.5 pd=4 as=3 ps=8
m237 vdd 1551 4126 vdd p l=0.54 w=3 ad=1.5 pd=4 as=2.7 ps=7.8
m238 4152 1565 vdd vdd p l=0.54 w=3 ad=2.7 pd=7.8 as=1.5 ps=4
m239 vdd 1567 4152 vdd p l=0.54 w=3 ad=1.5 pd=4 as=3 ps=8
m240 4153 1569 vdd vdd p l=0.54 w=3 ad=1.5 pd=4 as=3 ps=8
m241 vdd 1571 4153 vdd p l=0.54 w=3 ad=1.5 pd=4 as=3 ps=8
m242 4154 1573 vdd vdd p l=0.54 w=3 ad=1.5 pd=4 as=3 ps=8
m243 vdd 1591 4154 vdd p l=0.54 w=3 ad=1.5 pd=4 as=2.7 ps=7.8
m244 4180 1605 vdd vdd p l=0.54 w=3 ad=2.7 pd=7.8 as=1.5 ps=4
m245 vdd 1607 4180 vdd p l=0.54 w=3 ad=1.5 pd=4 as=3 ps=8
m246 4181 1609 vdd vdd p l=0.54 w=3 ad=1.5 pd=4 as=3 ps=8
m247 vdd 1611 4181 vdd p l=0.54 w=3 ad=1.5 pd=4 as=3 ps=8
m248 4182 1613 vdd vdd p l=0.54 w=3 ad=1.5 pd=4 as=3 ps=8
m249 vdd 1631 4182 vdd p l=0.54 w=3 ad=1.5 pd=4 as=2.7 ps=7.8
m250 4208 1645 vdd vdd p l=0.54 w=3 ad=2.7 pd=7.8 as=1.5 ps=4
m251 vdd 1647 4208 vdd p l=0.54 w=3 ad=1.5 pd=4 as=3 ps=8
m252 4209 1649 vdd vdd p l=0.54 w=3 ad=1.5 pd=4 as=3 ps=8
m253 vdd 1651 4209 vdd p l=0.54 w=3 ad=1.5 pd=4 as=3 ps=8
m254 4210 1653 vdd vdd p l=0.54 w=3 ad=1.5 pd=4 as=3 ps=8
m255 vdd 1671 4210 vdd p l=0.54 w=3 ad=1.5 pd=4 as=2.7 ps=7.8
m256 4236 1685 vdd vdd p l=0.54 w=3 ad=2.7 pd=7.8 as=1.5 ps=4
m257 vdd 1687 4236 vdd p l=0.54 w=3 ad=1.5 pd=4 as=3 ps=8
m258 4237 1689 vdd vdd p l=0.54 w=3 ad=1.5 pd=4 as=3 ps=8
m259 vdd 1691 4237 vdd p l=0.54 w=3 ad=1.5 pd=4 as=3 ps=8
m260 4238 1693 vdd vdd p l=0.54 w=3 ad=1.5 pd=4 as=3 ps=8
m261 vdd 1711 4238 vdd p l=0.54 w=3 ad=1.5 pd=4 as=2.7 ps=7.8
m262 4265 1725 vdd vdd p l=0.54 w=3 ad=2.7 pd=7.8 as=1.5 ps=4
m263 vdd 1727 4265 vdd p l=0.54 w=3 ad=1.5 pd=4 as=3 ps=8
m264 4266 1729 vdd vdd p l=0.54 w=3 ad=1.5 pd=4 as=3 ps=8
m265 vdd 1731 4266 vdd p l=0.54 w=3 ad=1.5 pd=4 as=3 ps=8
m266 4267 1733 vdd vdd p l=0.54 w=3 ad=1.5 pd=4 as=3 ps=8
m267 vdd 1751 4267 vdd p l=0.54 w=3 ad=1.5 pd=4 as=2.7 ps=7.8
m268 4293 1765 vdd vdd p l=0.54 w=3 ad=2.7 pd=7.8 as=1.5 ps=4
m269 vdd 1767 4293 vdd p l=0.54 w=3 ad=1.5 pd=4 as=3 ps=8
m270 4294 1769 vdd vdd p l=0.54 w=3 ad=1.5 pd=4 as=3 ps=8
m271 vdd 1771 4294 vdd p l=0.54 w=3 ad=1.5 pd=4 as=3 ps=8
m272 4295 1773 vdd vdd p l=0.54 w=3 ad=1.5 pd=4 as=3 ps=8
m273 vdd 1791 4295 vdd p l=0.54 w=3 ad=1.5 pd=4 as=2.7 ps=7.8
m274 4321 1805 vdd vdd p l=0.54 w=3 ad=2.7 pd=7.8 as=1.5 ps=4
m275 vdd 1807 4321 vdd p l=0.54 w=3 ad=1.5 pd=4 as=3 ps=8
m276 4322 1809 vdd vdd p l=0.54 w=3 ad=1.5 pd=4 as=3 ps=8
m277 vdd 1811 4322 vdd p l=0.54 w=3 ad=1.5 pd=4 as=3 ps=8
m278 4323 1813 vdd vdd p l=0.54 w=3 ad=1.5 pd=4 as=3 ps=8
m279 vdd 1831 4323 vdd p l=0.54 w=3 ad=1.5 pd=4 as=2.7 ps=7.8
m280 4349 1845 vdd vdd p l=0.54 w=3 ad=2.7 pd=7.8 as=1.5 ps=4
m281 vdd 1847 4349 vdd p l=0.54 w=3 ad=1.5 pd=4 as=3 ps=8
m282 4350 1849 vdd vdd p l=0.54 w=3 ad=1.5 pd=4 as=3 ps=8
m283 vdd 1851 4350 vdd p l=0.54 w=3 ad=1.5 pd=4 as=3 ps=8
m284 4351 1853 vdd vdd p l=0.54 w=3 ad=1.5 pd=4 as=3 ps=8
m285 vdd 1871 4351 vdd p l=0.54 w=3 ad=1.5 pd=4 as=2.7 ps=7.8
m286 4377 1885 vdd vdd p l=0.54 w=3 ad=2.7 pd=7.8 as=1.5 ps=4
m287 vdd 1887 4377 vdd p l=0.54 w=3 ad=1.5 pd=4 as=3 ps=8
m288 4378 1889 vdd vdd p l=0.54 w=3 ad=1.5 pd=4 as=3 ps=8
m289 vdd 1891 4378 vdd p l=0.54 w=3 ad=1.5 pd=4 as=3 ps=8
m290 4379 1893 vdd vdd p l=0.54 w=3 ad=1.5 pd=4 as=3 ps=8
m291 vdd 1911 4379 vdd p l=0.54 w=3 ad=1.5 pd=4 as=2.7 ps=7.8
m292 4405 1925 vdd vdd p l=0.54 w=3 ad=2.7 pd=7.8 as=1.5 ps=4
m293 vdd 1927 4405 vdd p l=0.54 w=3 ad=1.5 pd=4 as=3 ps=8
m294 4406 1929 vdd vdd p l=0.54 w=3 ad=1.5 pd=4 as=3 ps=8
m295 vdd 1931 4406 vdd p l=0.54 w=3 ad=1.5 pd=4 as=3 ps=8
m296 4407 1933 vdd vdd p l=0.54 w=3 ad=1.5 pd=4 as=3 ps=8
m297 vdd 1951 4407 vdd p l=0.54 w=3 ad=1.5 pd=4 as=2.7 ps=7.8
m298 4433 1965 vdd vdd p l=0.54 w=3 ad=2.7 pd=7.8 as=1.5 ps=4
m299 vdd 1967 4433 vdd p l=0.54 w=3 ad=1.5 pd=4 as=3 ps=8
m300 4434 1969 vdd vdd p l=0.54 w=3 ad=1.5 pd=4 as=3 ps=8
m301 vdd 1971 4434 vdd p l=0.54 w=3 ad=1.5 pd=4 as=3 ps=8
m302 4435 1973 vdd vdd p l=0.54 w=3 ad=1.5 pd=4 as=3 ps=8
m303 vdd 1991 4435 vdd p l=0.54 w=3 ad=1.5 pd=4 as=2.7 ps=7.8
m304 4461 2005 vdd vdd p l=0.54 w=3 ad=2.7 pd=7.8 as=1.5 ps=4
m305 vdd 2007 4461 vdd p l=0.54 w=3 ad=1.5 pd=4 as=3 ps=8
m306 4462 2009 vdd vdd p l=0.54 w=3 ad=1.5 pd=4 as=3 ps=8
m307 vdd 2011 4462 vdd p l=0.54 w=3 ad=1.5 pd=4 as=3 ps=8
m308 4463 2013 vdd vdd p l=0.54 w=3 ad=1.5 pd=4 as=3 ps=8
m309 vdd 2031 4463 vdd p l=0.54 w=3 ad=1.5 pd=4 as=2.7 ps=7.8
m310 4489 2045 vdd vdd p l=0.54 w=3 ad=2.7 pd=7.8 as=1.5 ps=4
m311 vdd 2047 4489 vdd p l=0.54 w=3 ad=1.5 pd=4 as=3 ps=8
m312 4490 2049 vdd vdd p l=0.54 w=3 ad=1.5 pd=4 as=3 ps=8
m313 vdd 2051 4490 vdd p l=0.54 w=3 ad=1.5 pd=4 as=3 ps=8
m314 4491 2053 vdd vdd p l=0.54 w=3 ad=1.5 pd=4 as=3 ps=8
m315 vdd 2071 4491 vdd p l=0.54 w=3 ad=1.5 pd=4 as=2.7 ps=7.8
m316 4517 2085 vdd vdd p l=0.54 w=3 ad=2.7 pd=7.8 as=1.5 ps=4
m317 vdd 2087 4517 vdd p l=0.54 w=3 ad=1.5 pd=4 as=3 ps=8
m318 4518 2089 vdd vdd p l=0.54 w=3 ad=1.5 pd=4 as=3 ps=8
m319 vdd 2091 4518 vdd p l=0.54 w=3 ad=1.5 pd=4 as=3 ps=8
m320 4519 2093 vdd vdd p l=0.54 w=3 ad=1.5 pd=4 as=3 ps=8
m321 vdd 2111 4519 vdd p l=0.54 w=3 ad=1.5 pd=4 as=2.7 ps=7.8
m322 4545 2125 vdd vdd p l=0.54 w=3 ad=2.7 pd=7.8 as=1.5 ps=4
m323 vdd 2127 4545 vdd p l=0.54 w=3 ad=1.5 pd=4 as=3 ps=8
m324 4546 2129 vdd vdd p l=0.54 w=3 ad=1.5 pd=4 as=3 ps=8
m325 vdd 2131 4546 vdd p l=0.54 w=3 ad=1.5 pd=4 as=3 ps=8
m326 4547 2133 vdd vdd p l=0.54 w=3 ad=1.5 pd=4 as=3 ps=8
m327 vdd 2151 4547 vdd p l=0.54 w=3 ad=1.5 pd=4 as=2.7 ps=7.8
m328 4573 2165 vdd vdd p l=0.54 w=3 ad=2.7 pd=7.8 as=1.5 ps=4
m329 vdd 2167 4573 vdd p l=0.54 w=3 ad=1.5 pd=4 as=3 ps=8
m330 4574 2169 vdd vdd p l=0.54 w=3 ad=1.5 pd=4 as=3 ps=8
m331 vdd 2171 4574 vdd p l=0.54 w=3 ad=1.5 pd=4 as=3 ps=8
m332 4575 2173 vdd vdd p l=0.54 w=3 ad=1.5 pd=4 as=3 ps=8
m333 vdd 2191 4575 vdd p l=0.54 w=3 ad=1.5 pd=4 as=2.7 ps=7.8
m334 4601 2205 vdd vdd p l=0.54 w=3 ad=2.7 pd=7.8 as=1.5 ps=4
m335 vdd 2207 4601 vdd p l=0.54 w=3 ad=1.5 pd=4 as=3 ps=8
m336 4602 2209 vdd vdd p l=0.54 w=3 ad=1.5 pd=4 as=3 ps=8
m337 vdd 2211 4602 vdd p l=0.54 w=3 ad=1.5 pd=4 as=3 ps=8
m338 4603 2213 vdd vdd p l=0.54 w=3 ad=1.5 pd=4 as=3 ps=8
m339 vdd 2231 4603 vdd p l=0.54 w=3 ad=1.5 pd=4 as=2.7 ps=7.8
m340 4629 2245 vdd vdd p l=0.54 w=3 ad=2.7 pd=7.8 as=1.5 ps=4
m341 vdd 2247 4629 vdd p l=0.54 w=3 ad=1.5 pd=4 as=3 ps=8
m342 4630 2249 vdd vdd p l=0.54 w=3 ad=1.5 pd=4 as=3 ps=8
m343 vdd 2251 4630 vdd p l=0.54 w=3 ad=1.5 pd=4 as=3 ps=8
m344 4631 2253 vdd vdd p l=0.54 w=3 ad=1.5 pd=4 as=3 ps=8
m345 vdd 2271 4631 vdd p l=0.54 w=3 ad=1.5 pd=4 as=2.7 ps=7.8
m346 4657 2285 vdd vdd p l=0.54 w=3 ad=2.7 pd=7.8 as=1.5 ps=4
m347 vdd 2287 4657 vdd p l=0.54 w=3 ad=1.5 pd=4 as=3 ps=8
m348 4658 2289 vdd vdd p l=0.54 w=3 ad=1.5 pd=4 as=3 ps=8
m349 vdd 2291 4658 vdd p l=0.54 w=3 ad=1.5 pd=4 as=3 ps=8
m350 4659 2293 vdd vdd p l=0.54 w=3 ad=1.5 pd=4 as=3 ps=8
m351 vdd 2311 4659 vdd p l=0.54 w=3 ad=1.5 pd=4 as=2.7 ps=7.8
m352 4685 2325 vdd vdd p l=0.54 w=3 ad=2.7 pd=7.8 as=1.5 ps=4
m353 vdd 2327 4685 vdd p l=0.54 w=3 ad=1.5 pd=4 as=3 ps=8
m354 4686 2329 vdd vdd p l=0.54 w=3 ad=1.5 pd=4 as=3 ps=8
m355 vdd 2331 4686 vdd p l=0.54 w=3 ad=1.5 pd=4 as=3 ps=8
m356 4687 2333 vdd vdd p l=0.54 w=3 ad=1.5 pd=4 as=3 ps=8
m357 vdd 2351 4687 vdd p l=0.54 w=3 ad=1.5 pd=4 as=2.7 ps=7.8
m358 4714 2365 vdd vdd p l=0.54 w=3 ad=2.7 pd=7.8 as=1.5 ps=4
m359 vdd 2367 4714 vdd p l=0.54 w=3 ad=1.5 pd=4 as=3 ps=8
m360 4715 2369 vdd vdd p l=0.54 w=3 ad=1.5 pd=4 as=3 ps=8
m361 vdd 2371 4715 vdd p l=0.54 w=3 ad=1.5 pd=4 as=3 ps=8
m362 4716 2373 vdd vdd p l=0.54 w=3 ad=1.5 pd=4 as=3 ps=8
m363 vdd 2391 4716 vdd p l=0.54 w=3 ad=1.5 pd=4 as=2.7 ps=7.8
m364 4742 2405 vdd vdd p l=0.54 w=3 ad=2.7 pd=7.8 as=1.5 ps=4
m365 vdd 2407 4742 vdd p l=0.54 w=3 ad=1.5 pd=4 as=3 ps=8
m366 4743 2409 vdd vdd p l=0.54 w=3 ad=1.5 pd=4 as=3 ps=8
m367 vdd 2411 4743 vdd p l=0.54 w=3 ad=1.5 pd=4 as=3 ps=8
m368 4744 2413 vdd vdd p l=0.54 w=3 ad=1.5 pd=4 as=3 ps=8
m369 vdd 2431 4744 vdd p l=0.54 w=3 ad=1.5 pd=4 as=2.7 ps=7.8
m370 4770 2445 vdd vdd p l=0.54 w=3 ad=2.7 pd=7.8 as=1.5 ps=4
m371 vdd 2447 4770 vdd p l=0.54 w=3 ad=1.5 pd=4 as=3 ps=8
m372 4771 2449 vdd vdd p l=0.54 w=3 ad=1.5 pd=4 as=3 ps=8
m373 vdd 2451 4771 vdd p l=0.54 w=3 ad=1.5 pd=4 as=3 ps=8
m374 4772 2453 vdd vdd p l=0.54 w=3 ad=1.5 pd=4 as=3 ps=8
m375 vdd 2471 4772 vdd p l=0.54 w=3 ad=1.5 pd=4 as=2.7 ps=7.8
m376 4798 2485 vdd vdd p l=0.54 w=3 ad=2.7 pd=7.8 as=1.5 ps=4
m377 vdd 2487 4798 vdd p l=0.54 w=3 ad=1.5 pd=4 as=3 ps=8
m378 4799 2489 vdd vdd p l=0.54 w=3 ad=1.5 pd=4 as=3 ps=8
m379 vdd 2491 4799 vdd p l=0.54 w=3 ad=1.5 pd=4 as=3 ps=8
m380 4800 2493 vdd vdd p l=0.54 w=3 ad=1.5 pd=4 as=3 ps=8
m381 vdd 2511 4800 vdd p l=0.54 w=3 ad=1.5 pd=4 as=2.7 ps=7.8
m382 4826 2525 vdd vdd p l=0.54 w=3 ad=2.7 pd=7.8 as=1.5 ps=4
m383 vdd 2527 4826 vdd p l=0.54 w=3 ad=1.5 pd=4 as=3 ps=8
m384 4827 2529 vdd vdd p l=0.54 w=3 ad=1.5 pd=4 as=3 ps=8
m385 vdd 2531 4827 vdd p l=0.54 w=3 ad=1.5 pd=4 as=3 ps=8
m386 4828 2533 vdd vdd p l=0.54 w=3 ad=1.5 pd=4 as=3 ps=8
m387 vdd 2551 4828 vdd p l=0.54 w=3 ad=1.5 pd=4 as=2.7 ps=7.8
m388 4854 2565 vdd vdd p l=0.54 w=3 ad=2.7 pd=7.8 as=1.5 ps=4
m389 vdd 2567 4854 vdd p l=0.54 w=3 ad=1.5 pd=4 as=3 ps=8
m390 4855 2569 vdd vdd p l=0.54 w=3 ad=1.5 pd=4 as=3 ps=8
m391 vdd 2571 4855 vdd p l=0.54 w=3 ad=1.5 pd=4 as=3 ps=8
m392 4856 2573 vdd vdd p l=0.54 w=3 ad=1.5 pd=4 as=3 ps=8
m393 vdd 2591 4856 vdd p l=0.54 w=3 ad=1.5 pd=4 as=2.7 ps=7.8
m394 4882 2605 vdd vdd p l=0.54 w=3 ad=2.7 pd=7.8 as=1.5 ps=4
m395 vdd 2607 4882 vdd p l=0.54 w=3 ad=1.5 pd=4 as=3 ps=8
m396 4883 2609 vdd vdd p l=0.54 w=3 ad=1.5 pd=4 as=3 ps=8
m397 vdd 2611 4883 vdd p l=0.54 w=3 ad=1.5 pd=4 as=3 ps=8
m398 4884 2613 vdd vdd p l=0.54 w=3 ad=1.5 pd=4 as=3 ps=8
m399 vdd 2631 4884 vdd p l=0.54 w=3 ad=1.5 pd=4 as=2.7 ps=7.8
m400 4910 2645 vdd vdd p l=0.54 w=3 ad=2.7 pd=7.8 as=1.5 ps=4
m401 vdd 2647 4910 vdd p l=0.54 w=3 ad=1.5 pd=4 as=3 ps=8
m402 4911 2649 vdd vdd p l=0.54 w=3 ad=1.5 pd=4 as=3 ps=8
m403 vdd 2651 4911 vdd p l=0.54 w=3 ad=1.5 pd=4 as=3 ps=8
m404 4912 2653 vdd vdd p l=0.54 w=3 ad=1.5 pd=4 as=3 ps=8
m405 vdd 2671 4912 vdd p l=0.54 w=3 ad=1.5 pd=4 as=2.7 ps=7.8
m406 4938 2685 vdd vdd p l=0.54 w=3 ad=2.7 pd=7.8 as=1.5 ps=4
m407 vdd 2687 4938 vdd p l=0.54 w=3 ad=1.5 pd=4 as=3 ps=8
m408 4939 2689 vdd vdd p l=0.54 w=3 ad=1.5 pd=4 as=3 ps=8
m409 vdd 2691 4939 vdd p l=0.54 w=3 ad=1.5 pd=4 as=3 ps=8
m410 4940 2693 vdd vdd p l=0.54 w=3 ad=1.5 pd=4 as=3 ps=8
m411 vdd 2711 4940 vdd p l=0.54 w=3 ad=1.5 pd=4 as=2.7 ps=7.8
m412 4966 2725 vdd vdd p l=0.54 w=3 ad=2.7 pd=7.8 as=1.5 ps=4
m413 vdd 2727 4966 vdd p l=0.54 w=3 ad=1.5 pd=4 as=3 ps=8
m414 4967 2729 vdd vdd p l=0.54 w=3 ad=1.5 pd=4 as=3 ps=8
m415 vdd 2731 4967 vdd p l=0.54 w=3 ad=1.5 pd=4 as=3 ps=8
m416 4968 2733 vdd vdd p l=0.54 w=3 ad=1.5 pd=4 as=3 ps=8
m417 vdd 2751 4968 vdd p l=0.54 w=3 ad=1.5 pd=4 as=2.7 ps=7.8
m418 3026 2915 gnd 3487 n l=0.54 w=1.5 ad=1.35 pd=4.8 as=0.75 ps=2.5
m419 gnd 6 3026 3487 n l=0.54 w=1.5 ad=0.75 pd=2.5 as=1.5 ps=5
m420 3027 8 gnd 3487 n l=0.54 w=1.5 ad=0.75 pd=2.5 as=1.5 ps=5
m421 gnd 10 3027 3487 n l=0.54 w=1.5 ad=0.75 pd=2.5 as=1.5 ps=5
m422 3028 12 gnd 3487 n l=0.54 w=1.5 ad=0.75 pd=2.5 as=1.5 ps=5
m423 gnd 30 3028 3487 n l=0.54 w=1.5 ad=0.75 pd=2.5 as=1.35 ps=4.8
m424 3054 2916 gnd 3487 n l=0.54 w=1.5 ad=1.35 pd=4.8 as=0.75 ps=2.5
m425 gnd 46 3054 3487 n l=0.54 w=1.5 ad=0.75 pd=2.5 as=1.5 ps=5
m426 3055 48 gnd 3487 n l=0.54 w=1.5 ad=0.75 pd=2.5 as=1.5 ps=5
m427 gnd 50 3055 3487 n l=0.54 w=1.5 ad=0.75 pd=2.5 as=1.5 ps=5
m428 3056 52 gnd 3487 n l=0.54 w=1.5 ad=0.75 pd=2.5 as=1.5 ps=5
m429 gnd 70 3056 3487 n l=0.54 w=1.5 ad=0.75 pd=2.5 as=1.35 ps=4.8
m430 3082 2917 gnd 3487 n l=0.54 w=1.5 ad=1.35 pd=4.8 as=0.75 ps=2.5
m431 gnd 86 3082 3487 n l=0.54 w=1.5 ad=0.75 pd=2.5 as=1.5 ps=5
m432 3083 88 gnd 3487 n l=0.54 w=1.5 ad=0.75 pd=2.5 as=1.5 ps=5
m433 gnd 90 3083 3487 n l=0.54 w=1.5 ad=0.75 pd=2.5 as=1.5 ps=5
m434 3084 92 gnd 3487 n l=0.54 w=1.5 ad=0.75 pd=2.5 as=1.5 ps=5
m435 gnd 110 3084 3487 n l=0.54 w=1.5 ad=0.75 pd=2.5 as=1.35 ps=4.8
m436 3110 2918 gnd 3487 n l=0.54 w=1.5 ad=1.35 pd=4.8 as=0.75 ps=2.5
m437 gnd 126 3110 3487 n l=0.54 w=1.5 ad=0.75 pd=2.5 as=1.5 ps=5
m438 3111 128 gnd 3487 n l=0.54 w=1.5 ad=0.75 pd=2.5 as=1.5 ps=5
m439 gnd 130 3111 3487 n l=0.54 w=1.5 ad=0.75 pd=2.5 as=1.5 ps=5
m440 3112 132 gnd 3487 n l=0.54 w=1.5 ad=0.75 pd=2.5 as=1.5 ps=5
m441 gnd 150 3112 3487 n l=0.54 w=1.5 ad=0.75 pd=2.5 as=1.35 ps=4.8
m442 3138 2921 gnd 3487 n l=0.54 w=1.5 ad=1.35 pd=4.8 as=0.75 ps=2.5
m443 gnd 166 3138 3487 n l=0.54 w=1.5 ad=0.75 pd=2.5 as=1.5 ps=5
m444 3139 168 gnd 3487 n l=0.54 w=1.5 ad=0.75 pd=2.5 as=1.5 ps=5
m445 gnd 170 3139 3487 n l=0.54 w=1.5 ad=0.75 pd=2.5 as=1.5 ps=5
m446 3140 172 gnd 3487 n l=0.54 w=1.5 ad=0.75 pd=2.5 as=1.5 ps=5
m447 gnd 190 3140 3487 n l=0.54 w=1.5 ad=0.75 pd=2.5 as=1.35 ps=4.8
m448 3001 3148 gnd 3487 n l=0.54 w=1.5 ad=1.17 pd=4.8 as=0.75 ps=2.5
m449 gnd 3150 3001 3487 n l=0.54 w=1.5 ad=0.75 pd=2.5 as=1.5 ps=5
m450 3002 3152 gnd 3487 n l=0.54 w=1.5 ad=0.75 pd=2.5 as=1.5 ps=5
m451 gnd 3154 3002 3487 n l=0.54 w=1.5 ad=0.75 pd=2.5 as=1.17 ps=4.8
m452 3198 2921 gnd 3487 n l=0.54 w=1.5 ad=1.35 pd=4.8 as=0.75 ps=2.5
m453 gnd 206 3198 3487 n l=0.54 w=1.5 ad=0.75 pd=2.5 as=1.5 ps=5
m454 3199 208 gnd 3487 n l=0.54 w=1.5 ad=0.75 pd=2.5 as=1.5 ps=5
m455 gnd 210 3199 3487 n l=0.54 w=1.5 ad=0.75 pd=2.5 as=1.5 ps=5
m456 3200 212 gnd 3487 n l=0.54 w=1.5 ad=0.75 pd=2.5 as=1.5 ps=5
m457 gnd 230 3200 3487 n l=0.54 w=1.5 ad=0.75 pd=2.5 as=1.35 ps=4.8
m458 3226 2922 gnd 3487 n l=0.54 w=1.5 ad=1.35 pd=4.8 as=0.75 ps=2.5
m459 gnd 246 3226 3487 n l=0.54 w=1.5 ad=0.75 pd=2.5 as=1.5 ps=5
m460 3227 248 gnd 3487 n l=0.54 w=1.5 ad=0.75 pd=2.5 as=1.5 ps=5
m461 gnd 250 3227 3487 n l=0.54 w=1.5 ad=0.75 pd=2.5 as=1.5 ps=5
m462 3228 252 gnd 3487 n l=0.54 w=1.5 ad=0.75 pd=2.5 as=1.5 ps=5
m463 gnd 270 3228 3487 n l=0.54 w=1.5 ad=0.75 pd=2.5 as=1.35 ps=4.8
m464 3254 2923 gnd 3487 n l=0.54 w=1.5 ad=1.35 pd=4.8 as=0.75 ps=2.5
m465 gnd 286 3254 3487 n l=0.54 w=1.5 ad=0.75 pd=2.5 as=1.5 ps=5
m466 3255 288 gnd 3487 n l=0.54 w=1.5 ad=0.75 pd=2.5 as=1.5 ps=5
m467 gnd 290 3255 3487 n l=0.54 w=1.5 ad=0.75 pd=2.5 as=1.5 ps=5
m468 3256 292 gnd 3487 n l=0.54 w=1.5 ad=0.75 pd=2.5 as=1.5 ps=5
m469 gnd 310 3256 3487 n l=0.54 w=1.5 ad=0.75 pd=2.5 as=1.35 ps=4.8
m470 3282 2924 gnd 3487 n l=0.54 w=1.5 ad=1.35 pd=4.8 as=0.75 ps=2.5
m471 gnd 326 3282 3487 n l=0.54 w=1.5 ad=0.75 pd=2.5 as=1.5 ps=5
m472 3283 328 gnd 3487 n l=0.54 w=1.5 ad=0.75 pd=2.5 as=1.5 ps=5
m473 gnd 330 3283 3487 n l=0.54 w=1.5 ad=0.75 pd=2.5 as=1.5 ps=5
m474 3284 332 gnd 3487 n l=0.54 w=1.5 ad=0.75 pd=2.5 as=1.5 ps=5
m475 gnd 350 3284 3487 n l=0.54 w=1.5 ad=0.75 pd=2.5 as=1.35 ps=4.8
m476 3310 2925 gnd 3487 n l=0.54 w=1.5 ad=1.35 pd=4.8 as=0.75 ps=2.5
m477 gnd 366 3310 3487 n l=0.54 w=1.5 ad=0.75 pd=2.5 as=1.5 ps=5
m478 3311 368 gnd 3487 n l=0.54 w=1.5 ad=0.75 pd=2.5 as=1.5 ps=5
m479 gnd 370 3311 3487 n l=0.54 w=1.5 ad=0.75 pd=2.5 as=1.5 ps=5
m480 3312 372 gnd 3487 n l=0.54 w=1.5 ad=0.75 pd=2.5 as=1.5 ps=5
m481 gnd 390 3312 3487 n l=0.54 w=1.5 ad=0.75 pd=2.5 as=1.35 ps=4.8
m482 3338 2926 gnd 3487 n l=0.54 w=1.5 ad=1.35 pd=4.8 as=0.75 ps=2.5
m483 gnd 406 3338 3487 n l=0.54 w=1.5 ad=0.75 pd=2.5 as=1.5 ps=5
m484 3339 408 gnd 3487 n l=0.54 w=1.5 ad=0.75 pd=2.5 as=1.5 ps=5
m485 gnd 410 3339 3487 n l=0.54 w=1.5 ad=0.75 pd=2.5 as=1.5 ps=5
m486 3340 412 gnd 3487 n l=0.54 w=1.5 ad=0.75 pd=2.5 as=1.5 ps=5
m487 gnd 430 3340 3487 n l=0.54 w=1.5 ad=0.75 pd=2.5 as=1.35 ps=4.8
m488 3366 2927 gnd 3487 n l=0.54 w=1.5 ad=1.35 pd=4.8 as=0.75 ps=2.5
m489 gnd 446 3366 3487 n l=0.54 w=1.5 ad=0.75 pd=2.5 as=1.5 ps=5
m490 3367 448 gnd 3487 n l=0.54 w=1.5 ad=0.75 pd=2.5 as=1.5 ps=5
m491 gnd 450 3367 3487 n l=0.54 w=1.5 ad=0.75 pd=2.5 as=1.5 ps=5
m492 3368 452 gnd 3487 n l=0.54 w=1.5 ad=0.75 pd=2.5 as=1.5 ps=5
m493 gnd 470 3368 3487 n l=0.54 w=1.5 ad=0.75 pd=2.5 as=1.35 ps=4.8
m494 3394 2929 gnd 3487 n l=0.54 w=1.5 ad=1.35 pd=4.8 as=0.75 ps=2.5
m495 gnd 486 3394 3487 n l=0.54 w=1.5 ad=0.75 pd=2.5 as=1.5 ps=5
m496 3395 488 gnd 3487 n l=0.54 w=1.5 ad=0.75 pd=2.5 as=1.5 ps=5
m497 gnd 490 3395 3487 n l=0.54 w=1.5 ad=0.75 pd=2.5 as=1.5 ps=5
m498 3396 492 gnd 3487 n l=0.54 w=1.5 ad=0.75 pd=2.5 as=1.5 ps=5
m499 gnd 510 3396 3487 n l=0.54 w=1.5 ad=0.75 pd=2.5 as=1.35 ps=4.8
m500 3422 2929 gnd 3487 n l=0.54 w=1.5 ad=1.35 pd=4.8 as=0.75 ps=2.5
m501 gnd 526 3422 3487 n l=0.54 w=1.5 ad=0.75 pd=2.5 as=1.5 ps=5
m502 3423 528 gnd 3487 n l=0.54 w=1.5 ad=0.75 pd=2.5 as=1.5 ps=5
m503 gnd 530 3423 3487 n l=0.54 w=1.5 ad=0.75 pd=2.5 as=1.5 ps=5
m504 3424 532 gnd 3487 n l=0.54 w=1.5 ad=0.75 pd=2.5 as=1.5 ps=5
m505 gnd 550 3424 3487 n l=0.54 w=1.5 ad=0.75 pd=2.5 as=1.35 ps=4.8
m506 3450 2932 gnd 3487 n l=0.54 w=1.5 ad=1.35 pd=4.8 as=0.75 ps=2.5
m507 gnd 566 3450 3487 n l=0.54 w=1.5 ad=0.75 pd=2.5 as=1.5 ps=5
m508 3451 568 gnd 3487 n l=0.54 w=1.5 ad=0.75 pd=2.5 as=1.5 ps=5
m509 gnd 570 3451 3487 n l=0.54 w=1.5 ad=0.75 pd=2.5 as=1.5 ps=5
m510 3452 572 gnd 3487 n l=0.54 w=1.5 ad=0.75 pd=2.5 as=1.5 ps=5
m511 gnd 590 3452 3487 n l=0.54 w=1.5 ad=0.75 pd=2.5 as=1.35 ps=4.8
m512 3478 2933 gnd 3487 n l=0.54 w=1.5 ad=1.35 pd=4.8 as=0.75 ps=2.5
m513 gnd 606 3478 3487 n l=0.54 w=1.5 ad=0.75 pd=2.5 as=1.5 ps=5
m514 3479 608 gnd 3487 n l=0.54 w=1.5 ad=0.75 pd=2.5 as=1.5 ps=5
m515 gnd 610 3479 3487 n l=0.54 w=1.5 ad=0.75 pd=2.5 as=1.5 ps=5
m516 3480 612 gnd 3487 n l=0.54 w=1.5 ad=0.75 pd=2.5 as=1.5 ps=5
m517 gnd 630 3480 3487 n l=0.54 w=1.5 ad=0.75 pd=2.5 as=1.35 ps=4.8
m518 3508 2934 gnd 3487 n l=0.54 w=1.5 ad=1.35 pd=4.8 as=0.75 ps=2.5
m519 gnd 646 3508 3487 n l=0.54 w=1.5 ad=0.75 pd=2.5 as=1.5 ps=5
m520 3509 648 gnd 3487 n l=0.54 w=1.5 ad=0.75 pd=2.5 as=1.5 ps=5
m521 gnd 650 3509 3487 n l=0.54 w=1.5 ad=0.75 pd=2.5 as=1.5 ps=5
m522 3510 652 gnd 3487 n l=0.54 w=1.5 ad=0.75 pd=2.5 as=1.5 ps=5
m523 gnd 670 3510 3487 n l=0.54 w=1.5 ad=0.75 pd=2.5 as=1.35 ps=4.8
m524 3536 2935 gnd 3487 n l=0.54 w=1.5 ad=1.35 pd=4.8 as=0.75 ps=2.5
m525 gnd 686 3536 3487 n l=0.54 w=1.5 ad=0.75 pd=2.5 as=1.5 ps=5
m526 3537 688 gnd 3487 n l=0.54 w=1.5 ad=0.75 pd=2.5 as=1.5 ps=5
m527 gnd 690 3537 3487 n l=0.54 w=1.5 ad=0.75 pd=2.5 as=1.5 ps=5
m528 3538 692 gnd 3487 n l=0.54 w=1.5 ad=0.75 pd=2.5 as=1.5 ps=5
m529 gnd 710 3538 3487 n l=0.54 w=1.5 ad=0.75 pd=2.5 as=1.35 ps=4.8
m530 3564 2936 gnd 3487 n l=0.54 w=1.5 ad=1.35 pd=4.8 as=0.75 ps=2.5
m531 gnd 726 3564 3487 n l=0.54 w=1.5 ad=0.75 pd=2.5 as=1.5 ps=5
m532 3565 728 gnd 3487 n l=0.54 w=1.5 ad=0.75 pd=2.5 as=1.5 ps=5
m533 gnd 730 3565 3487 n l=0.54 w=1.5 ad=0.75 pd=2.5 as=1.5 ps=5
m534 3566 732 gnd 3487 n l=0.54 w=1.5 ad=0.75 pd=2.5 as=1.5 ps=5
m535 gnd 750 3566 3487 n l=0.54 w=1.5 ad=0.75 pd=2.5 as=1.35 ps=4.8
m536 3592 2937 gnd 3487 n l=0.54 w=1.5 ad=1.35 pd=4.8 as=0.75 ps=2.5
m537 gnd 766 3592 3487 n l=0.54 w=1.5 ad=0.75 pd=2.5 as=1.5 ps=5
m538 3593 768 gnd 3487 n l=0.54 w=1.5 ad=0.75 pd=2.5 as=1.5 ps=5
m539 gnd 770 3593 3487 n l=0.54 w=1.5 ad=0.75 pd=2.5 as=1.5 ps=5
m540 3594 772 gnd 3487 n l=0.54 w=1.5 ad=0.75 pd=2.5 as=1.5 ps=5
m541 gnd 790 3594 3487 n l=0.54 w=1.5 ad=0.75 pd=2.5 as=1.35 ps=4.8
m542 3620 2939 gnd 3487 n l=0.54 w=1.5 ad=1.35 pd=4.8 as=0.75 ps=2.5
m543 gnd 806 3620 3487 n l=0.54 w=1.5 ad=0.75 pd=2.5 as=1.5 ps=5
m544 3621 808 gnd 3487 n l=0.54 w=1.5 ad=0.75 pd=2.5 as=1.5 ps=5
m545 gnd 810 3621 3487 n l=0.54 w=1.5 ad=0.75 pd=2.5 as=1.5 ps=5
m546 3622 812 gnd 3487 n l=0.54 w=1.5 ad=0.75 pd=2.5 as=1.5 ps=5
m547 gnd 830 3622 3487 n l=0.54 w=1.5 ad=0.75 pd=2.5 as=1.35 ps=4.8
m548 3648 2939 gnd 3487 n l=0.54 w=1.5 ad=1.35 pd=4.8 as=0.75 ps=2.5
m549 gnd 846 3648 3487 n l=0.54 w=1.5 ad=0.75 pd=2.5 as=1.5 ps=5
m550 3649 848 gnd 3487 n l=0.54 w=1.5 ad=0.75 pd=2.5 as=1.5 ps=5
m551 gnd 850 3649 3487 n l=0.54 w=1.5 ad=0.75 pd=2.5 as=1.5 ps=5
m552 3650 852 gnd 3487 n l=0.54 w=1.5 ad=0.75 pd=2.5 as=1.5 ps=5
m553 gnd 870 3650 3487 n l=0.54 w=1.5 ad=0.75 pd=2.5 as=1.35 ps=4.8
m554 3676 2940 gnd 3487 n l=0.54 w=1.5 ad=1.35 pd=4.8 as=0.75 ps=2.5
m555 gnd 886 3676 3487 n l=0.54 w=1.5 ad=0.75 pd=2.5 as=1.5 ps=5
m556 3677 888 gnd 3487 n l=0.54 w=1.5 ad=0.75 pd=2.5 as=1.5 ps=5
m557 gnd 890 3677 3487 n l=0.54 w=1.5 ad=0.75 pd=2.5 as=1.5 ps=5
m558 3678 892 gnd 3487 n l=0.54 w=1.5 ad=0.75 pd=2.5 as=1.5 ps=5
m559 gnd 910 3678 3487 n l=0.54 w=1.5 ad=0.75 pd=2.5 as=1.35 ps=4.8
m560 3704 2941 gnd 3487 n l=0.54 w=1.5 ad=1.35 pd=4.8 as=0.75 ps=2.5
m561 gnd 926 3704 3487 n l=0.54 w=1.5 ad=0.75 pd=2.5 as=1.5 ps=5
m562 3705 928 gnd 3487 n l=0.54 w=1.5 ad=0.75 pd=2.5 as=1.5 ps=5
m563 gnd 930 3705 3487 n l=0.54 w=1.5 ad=0.75 pd=2.5 as=1.5 ps=5
m564 3706 932 gnd 3487 n l=0.54 w=1.5 ad=0.75 pd=2.5 as=1.5 ps=5
m565 gnd 950 3706 3487 n l=0.54 w=1.5 ad=0.75 pd=2.5 as=1.35 ps=4.8
m566 3732 2942 gnd 3487 n l=0.54 w=1.5 ad=1.35 pd=4.8 as=0.75 ps=2.5
m567 gnd 966 3732 3487 n l=0.54 w=1.5 ad=0.75 pd=2.5 as=1.5 ps=5
m568 3733 968 gnd 3487 n l=0.54 w=1.5 ad=0.75 pd=2.5 as=1.5 ps=5
m569 gnd 970 3733 3487 n l=0.54 w=1.5 ad=0.75 pd=2.5 as=1.5 ps=5
m570 3734 972 gnd 3487 n l=0.54 w=1.5 ad=0.75 pd=2.5 as=1.5 ps=5
m571 gnd 990 3734 3487 n l=0.54 w=1.5 ad=0.75 pd=2.5 as=1.35 ps=4.8
m572 3760 2945 gnd 3487 n l=0.54 w=1.5 ad=1.35 pd=4.8 as=0.75 ps=2.5
m573 gnd 1006 3760 3487 n l=0.54 w=1.5 ad=0.75 pd=2.5 as=1.5 ps=5
m574 3761 1008 gnd 3487 n l=0.54 w=1.5 ad=0.75 pd=2.5 as=1.5 ps=5
m575 gnd 1010 3761 3487 n l=0.54 w=1.5 ad=0.75 pd=2.5 as=1.5 ps=5
m576 3762 1012 gnd 3487 n l=0.54 w=1.5 ad=0.75 pd=2.5 as=1.5 ps=5
m577 gnd 1030 3762 3487 n l=0.54 w=1.5 ad=0.75 pd=2.5 as=1.35 ps=4.8
m578 3788 2946 gnd 3487 n l=0.54 w=1.5 ad=1.35 pd=4.8 as=0.75 ps=2.5
m579 gnd 1046 3788 3487 n l=0.54 w=1.5 ad=0.75 pd=2.5 as=1.5 ps=5
m580 3789 1048 gnd 3487 n l=0.54 w=1.5 ad=0.75 pd=2.5 as=1.5 ps=5
m581 gnd 1050 3789 3487 n l=0.54 w=1.5 ad=0.75 pd=2.5 as=1.5 ps=5
m582 3790 1052 gnd 3487 n l=0.54 w=1.5 ad=0.75 pd=2.5 as=1.5 ps=5
m583 gnd 1070 3790 3487 n l=0.54 w=1.5 ad=0.75 pd=2.5 as=1.35 ps=4.8
m584 3816 2947 gnd 3487 n l=0.54 w=1.5 ad=1.35 pd=4.8 as=0.75 ps=2.5
m585 gnd 1086 3816 3487 n l=0.54 w=1.5 ad=0.75 pd=2.5 as=1.5 ps=5
m586 3817 1088 gnd 3487 n l=0.54 w=1.5 ad=0.75 pd=2.5 as=1.5 ps=5
m587 gnd 1090 3817 3487 n l=0.54 w=1.5 ad=0.75 pd=2.5 as=1.5 ps=5
m588 3818 1092 gnd 3487 n l=0.54 w=1.5 ad=0.75 pd=2.5 as=1.5 ps=5
m589 gnd 1110 3818 3487 n l=0.54 w=1.5 ad=0.75 pd=2.5 as=1.35 ps=4.8
m590 3845 2949 gnd 3487 n l=0.54 w=1.5 ad=1.35 pd=4.8 as=0.75 ps=2.5
m591 gnd 1126 3845 3487 n l=0.54 w=1.5 ad=0.75 pd=2.5 as=1.5 ps=5
m592 3846 1128 gnd 3487 n l=0.54 w=1.5 ad=0.75 pd=2.5 as=1.5 ps=5
m593 gnd 1130 3846 3487 n l=0.54 w=1.5 ad=0.75 pd=2.5 as=1.5 ps=5
m594 3847 1132 gnd 3487 n l=0.54 w=1.5 ad=0.75 pd=2.5 as=1.5 ps=5
m595 gnd 1150 3847 3487 n l=0.54 w=1.5 ad=0.75 pd=2.5 as=1.35 ps=4.8
m596 3873 2949 gnd 3487 n l=0.54 w=1.5 ad=1.35 pd=4.8 as=0.75 ps=2.5
m597 gnd 1166 3873 3487 n l=0.54 w=1.5 ad=0.75 pd=2.5 as=1.5 ps=5
m598 3874 1168 gnd 3487 n l=0.54 w=1.5 ad=0.75 pd=2.5 as=1.5 ps=5
m599 gnd 1170 3874 3487 n l=0.54 w=1.5 ad=0.75 pd=2.5 as=1.5 ps=5
m600 3875 1172 gnd 3487 n l=0.54 w=1.5 ad=0.75 pd=2.5 as=1.5 ps=5
m601 gnd 1190 3875 3487 n l=0.54 w=1.5 ad=0.75 pd=2.5 as=1.35 ps=4.8
m602 3901 2950 gnd 3487 n l=0.54 w=1.5 ad=1.35 pd=4.8 as=0.75 ps=2.5
m603 gnd 1206 3901 3487 n l=0.54 w=1.5 ad=0.75 pd=2.5 as=1.5 ps=5
m604 3902 1208 gnd 3487 n l=0.54 w=1.5 ad=0.75 pd=2.5 as=1.5 ps=5
m605 gnd 1210 3902 3487 n l=0.54 w=1.5 ad=0.75 pd=2.5 as=1.5 ps=5
m606 3903 1212 gnd 3487 n l=0.54 w=1.5 ad=0.75 pd=2.5 as=1.5 ps=5
m607 gnd 1230 3903 3487 n l=0.54 w=1.5 ad=0.75 pd=2.5 as=1.35 ps=4.8
m608 3929 2951 gnd 3487 n l=0.54 w=1.5 ad=1.35 pd=4.8 as=0.75 ps=2.5
m609 gnd 1246 3929 3487 n l=0.54 w=1.5 ad=0.75 pd=2.5 as=1.5 ps=5
m610 3930 1248 gnd 3487 n l=0.54 w=1.5 ad=0.75 pd=2.5 as=1.5 ps=5
m611 gnd 1250 3930 3487 n l=0.54 w=1.5 ad=0.75 pd=2.5 as=1.5 ps=5
m612 3931 1252 gnd 3487 n l=0.54 w=1.5 ad=0.75 pd=2.5 as=1.5 ps=5
m613 gnd 1270 3931 3487 n l=0.54 w=1.5 ad=0.75 pd=2.5 as=1.35 ps=4.8
m614 3959 2954 gnd 3487 n l=0.54 w=1.5 ad=1.35 pd=4.8 as=0.75 ps=2.5
m615 gnd 1286 3959 3487 n l=0.54 w=1.5 ad=0.75 pd=2.5 as=1.5 ps=5
m616 3960 1288 gnd 3487 n l=0.54 w=1.5 ad=0.75 pd=2.5 as=1.5 ps=5
m617 gnd 1290 3960 3487 n l=0.54 w=1.5 ad=0.75 pd=2.5 as=1.5 ps=5
m618 3961 1292 gnd 3487 n l=0.54 w=1.5 ad=0.75 pd=2.5 as=1.5 ps=5
m619 gnd 1310 3961 3487 n l=0.54 w=1.5 ad=0.75 pd=2.5 as=1.35 ps=4.8
m620 3987 2955 gnd 3487 n l=0.54 w=1.5 ad=1.35 pd=4.8 as=0.75 ps=2.5
m621 gnd 1326 3987 3487 n l=0.54 w=1.5 ad=0.75 pd=2.5 as=1.5 ps=5
m622 3988 1328 gnd 3487 n l=0.54 w=1.5 ad=0.75 pd=2.5 as=1.5 ps=5
m623 gnd 1330 3988 3487 n l=0.54 w=1.5 ad=0.75 pd=2.5 as=1.5 ps=5
m624 3989 1332 gnd 3487 n l=0.54 w=1.5 ad=0.75 pd=2.5 as=1.5 ps=5
m625 gnd 1350 3989 3487 n l=0.54 w=1.5 ad=0.75 pd=2.5 as=1.35 ps=4.8
m626 4015 2957 gnd 3487 n l=0.54 w=1.5 ad=1.35 pd=4.8 as=0.75 ps=2.5
m627 gnd 1366 4015 3487 n l=0.54 w=1.5 ad=0.75 pd=2.5 as=1.5 ps=5
m628 4016 1368 gnd 3487 n l=0.54 w=1.5 ad=0.75 pd=2.5 as=1.5 ps=5
m629 gnd 1370 4016 3487 n l=0.54 w=1.5 ad=0.75 pd=2.5 as=1.5 ps=5
m630 4017 1372 gnd 3487 n l=0.54 w=1.5 ad=0.75 pd=2.5 as=1.5 ps=5
m631 gnd 1390 4017 3487 n l=0.54 w=1.5 ad=0.75 pd=2.5 as=1.35 ps=4.8
m632 4043 2957 gnd 3487 n l=0.54 w=1.5 ad=1.35 pd=4.8 as=0.75 ps=2.5
m633 gnd 1406 4043 3487 n l=0.54 w=1.5 ad=0.75 pd=2.5 as=1.5 ps=5
m634 4044 1408 gnd 3487 n l=0.54 w=1.5 ad=0.75 pd=2.5 as=1.5 ps=5
m635 gnd 1410 4044 3487 n l=0.54 w=1.5 ad=0.75 pd=2.5 as=1.5 ps=5
m636 4045 1412 gnd 3487 n l=0.54 w=1.5 ad=0.75 pd=2.5 as=1.5 ps=5
m637 gnd 1430 4045 3487 n l=0.54 w=1.5 ad=0.75 pd=2.5 as=1.35 ps=4.8
m638 4071 2958 gnd 3487 n l=0.54 w=1.5 ad=1.35 pd=4.8 as=0.75 ps=2.5
m639 gnd 1446 4071 3487 n l=0.54 w=1.5 ad=0.75 pd=2.5 as=1.5 ps=5
m640 4072 1448 gnd 3487 n l=0.54 w=1.5 ad=0.75 pd=2.5 as=1.5 ps=5
m641 gnd 1450 4072 3487 n l=0.54 w=1.5 ad=0.75 pd=2.5 as=1.5 ps=5
m642 4073 1452 gnd 3487 n l=0.54 w=1.5 ad=0.75 pd=2.5 as=1.5 ps=5
m643 gnd 1470 4073 3487 n l=0.54 w=1.5 ad=0.75 pd=2.5 as=1.35 ps=4.8
m644 4099 2959 gnd 3487 n l=0.54 w=1.5 ad=1.35 pd=4.8 as=0.75 ps=2.5
m645 gnd 1486 4099 3487 n l=0.54 w=1.5 ad=0.75 pd=2.5 as=1.5 ps=5
m646 4100 1488 gnd 3487 n l=0.54 w=1.5 ad=0.75 pd=2.5 as=1.5 ps=5
m647 gnd 1490 4100 3487 n l=0.54 w=1.5 ad=0.75 pd=2.5 as=1.5 ps=5
m648 4101 1492 gnd 3487 n l=0.54 w=1.5 ad=0.75 pd=2.5 as=1.5 ps=5
m649 gnd 1510 4101 3487 n l=0.54 w=1.5 ad=0.75 pd=2.5 as=1.35 ps=4.8
m650 4127 2960 gnd 3487 n l=0.54 w=1.5 ad=1.35 pd=4.8 as=0.75 ps=2.5
m651 gnd 1526 4127 3487 n l=0.54 w=1.5 ad=0.75 pd=2.5 as=1.5 ps=5
m652 4128 1528 gnd 3487 n l=0.54 w=1.5 ad=0.75 pd=2.5 as=1.5 ps=5
m653 gnd 1530 4128 3487 n l=0.54 w=1.5 ad=0.75 pd=2.5 as=1.5 ps=5
m654 4129 1532 gnd 3487 n l=0.54 w=1.5 ad=0.75 pd=2.5 as=1.5 ps=5
m655 gnd 1550 4129 3487 n l=0.54 w=1.5 ad=0.75 pd=2.5 as=1.35 ps=4.8
m656 4155 2963 gnd 3487 n l=0.54 w=1.5 ad=1.35 pd=4.8 as=0.75 ps=2.5
m657 gnd 1566 4155 3487 n l=0.54 w=1.5 ad=0.75 pd=2.5 as=1.5 ps=5
m658 4156 1568 gnd 3487 n l=0.54 w=1.5 ad=0.75 pd=2.5 as=1.5 ps=5
m659 gnd 1570 4156 3487 n l=0.54 w=1.5 ad=0.75 pd=2.5 as=1.5 ps=5
m660 4157 1572 gnd 3487 n l=0.54 w=1.5 ad=0.75 pd=2.5 as=1.5 ps=5
m661 gnd 1590 4157 3487 n l=0.54 w=1.5 ad=0.75 pd=2.5 as=1.35 ps=4.8
m662 4183 2964 gnd 3487 n l=0.54 w=1.5 ad=1.35 pd=4.8 as=0.75 ps=2.5
m663 gnd 1606 4183 3487 n l=0.54 w=1.5 ad=0.75 pd=2.5 as=1.5 ps=5
m664 4184 1608 gnd 3487 n l=0.54 w=1.5 ad=0.75 pd=2.5 as=1.5 ps=5
m665 gnd 1610 4184 3487 n l=0.54 w=1.5 ad=0.75 pd=2.5 as=1.5 ps=5
m666 4185 1612 gnd 3487 n l=0.54 w=1.5 ad=0.75 pd=2.5 as=1.5 ps=5
m667 gnd 1630 4185 3487 n l=0.54 w=1.5 ad=0.75 pd=2.5 as=1.35 ps=4.8
m668 4211 2965 gnd 3487 n l=0.54 w=1.5 ad=1.35 pd=4.8 as=0.75 ps=2.5
m669 gnd 1646 4211 3487 n l=0.54 w=1.5 ad=0.75 pd=2.5 as=1.5 ps=5
m670 4212 1648 gnd 3487 n l=0.54 w=1.5 ad=0.75 pd=2.5 as=1.5 ps=5
m671 gnd 1650 4212 3487 n l=0.54 w=1.5 ad=0.75 pd=2.5 as=1.5 ps=5
m672 4213 1652 gnd 3487 n l=0.54 w=1.5 ad=0.75 pd=2.5 as=1.5 ps=5
m673 gnd 1670 4213 3487 n l=0.54 w=1.5 ad=0.75 pd=2.5 as=1.35 ps=4.8
m674 4239 2966 gnd 3487 n l=0.54 w=1.5 ad=1.35 pd=4.8 as=0.75 ps=2.5
m675 gnd 1686 4239 3487 n l=0.54 w=1.5 ad=0.75 pd=2.5 as=1.5 ps=5
m676 4240 1688 gnd 3487 n l=0.54 w=1.5 ad=0.75 pd=2.5 as=1.5 ps=5
m677 gnd 1690 4240 3487 n l=0.54 w=1.5 ad=0.75 pd=2.5 as=1.5 ps=5
m678 4241 1692 gnd 3487 n l=0.54 w=1.5 ad=0.75 pd=2.5 as=1.5 ps=5
m679 gnd 1710 4241 3487 n l=0.54 w=1.5 ad=0.75 pd=2.5 as=1.35 ps=4.8
m680 4268 2967 gnd 3487 n l=0.54 w=1.5 ad=1.35 pd=4.8 as=0.75 ps=2.5
m681 gnd 1726 4268 3487 n l=0.54 w=1.5 ad=0.75 pd=2.5 as=1.5 ps=5
m682 4269 1728 gnd 3487 n l=0.54 w=1.5 ad=0.75 pd=2.5 as=1.5 ps=5
m683 gnd 1730 4269 3487 n l=0.54 w=1.5 ad=0.75 pd=2.5 as=1.5 ps=5
m684 4270 1732 gnd 3487 n l=0.54 w=1.5 ad=0.75 pd=2.5 as=1.5 ps=5
m685 gnd 1750 4270 3487 n l=0.54 w=1.5 ad=0.75 pd=2.5 as=1.35 ps=4.8
m686 4296 2968 gnd 3487 n l=0.54 w=1.5 ad=1.35 pd=4.8 as=0.75 ps=2.5
m687 gnd 1766 4296 3487 n l=0.54 w=1.5 ad=0.75 pd=2.5 as=1.5 ps=5
m688 4297 1768 gnd 3487 n l=0.54 w=1.5 ad=0.75 pd=2.5 as=1.5 ps=5
m689 gnd 1770 4297 3487 n l=0.54 w=1.5 ad=0.75 pd=2.5 as=1.5 ps=5
m690 4298 1772 gnd 3487 n l=0.54 w=1.5 ad=0.75 pd=2.5 as=1.5 ps=5
m691 gnd 1790 4298 3487 n l=0.54 w=1.5 ad=0.75 pd=2.5 as=1.35 ps=4.8
m692 4324 2969 gnd 3487 n l=0.54 w=1.5 ad=1.35 pd=4.8 as=0.75 ps=2.5
m693 gnd 1806 4324 3487 n l=0.54 w=1.5 ad=0.75 pd=2.5 as=1.5 ps=5
m694 4325 1808 gnd 3487 n l=0.54 w=1.5 ad=0.75 pd=2.5 as=1.5 ps=5
m695 gnd 1810 4325 3487 n l=0.54 w=1.5 ad=0.75 pd=2.5 as=1.5 ps=5
m696 4326 1812 gnd 3487 n l=0.54 w=1.5 ad=0.75 pd=2.5 as=1.5 ps=5
m697 gnd 1830 4326 3487 n l=0.54 w=1.5 ad=0.75 pd=2.5 as=1.35 ps=4.8
m698 4352 2970 gnd 3487 n l=0.54 w=1.5 ad=1.35 pd=4.8 as=0.75 ps=2.5
m699 gnd 1846 4352 3487 n l=0.54 w=1.5 ad=0.75 pd=2.5 as=1.5 ps=5
m700 4353 1848 gnd 3487 n l=0.54 w=1.5 ad=0.75 pd=2.5 as=1.5 ps=5
m701 gnd 1850 4353 3487 n l=0.54 w=1.5 ad=0.75 pd=2.5 as=1.5 ps=5
m702 4354 1852 gnd 3487 n l=0.54 w=1.5 ad=0.75 pd=2.5 as=1.5 ps=5
m703 gnd 1870 4354 3487 n l=0.54 w=1.5 ad=0.75 pd=2.5 as=1.35 ps=4.8
m704 4380 2971 gnd 3487 n l=0.54 w=1.5 ad=1.35 pd=4.8 as=0.75 ps=2.5
m705 gnd 1886 4380 3487 n l=0.54 w=1.5 ad=0.75 pd=2.5 as=1.5 ps=5
m706 4381 1888 gnd 3487 n l=0.54 w=1.5 ad=0.75 pd=2.5 as=1.5 ps=5
m707 gnd 1890 4381 3487 n l=0.54 w=1.5 ad=0.75 pd=2.5 as=1.5 ps=5
m708 4382 1892 gnd 3487 n l=0.54 w=1.5 ad=0.75 pd=2.5 as=1.5 ps=5
m709 gnd 1910 4382 3487 n l=0.54 w=1.5 ad=0.75 pd=2.5 as=1.35 ps=4.8
m710 4408 2972 gnd 3487 n l=0.54 w=1.5 ad=1.35 pd=4.8 as=0.75 ps=2.5
m711 gnd 1926 4408 3487 n l=0.54 w=1.5 ad=0.75 pd=2.5 as=1.5 ps=5
m712 4409 1928 gnd 3487 n l=0.54 w=1.5 ad=0.75 pd=2.5 as=1.5 ps=5
m713 gnd 1930 4409 3487 n l=0.54 w=1.5 ad=0.75 pd=2.5 as=1.5 ps=5
m714 4410 1932 gnd 3487 n l=0.54 w=1.5 ad=0.75 pd=2.5 as=1.5 ps=5
m715 gnd 1950 4410 3487 n l=0.54 w=1.5 ad=0.75 pd=2.5 as=1.35 ps=4.8
m716 4436 2974 gnd 3487 n l=0.54 w=1.5 ad=1.35 pd=4.8 as=0.75 ps=2.5
m717 gnd 1966 4436 3487 n l=0.54 w=1.5 ad=0.75 pd=2.5 as=1.5 ps=5
m718 4437 1968 gnd 3487 n l=0.54 w=1.5 ad=0.75 pd=2.5 as=1.5 ps=5
m719 gnd 1970 4437 3487 n l=0.54 w=1.5 ad=0.75 pd=2.5 as=1.5 ps=5
m720 4438 1972 gnd 3487 n l=0.54 w=1.5 ad=0.75 pd=2.5 as=1.5 ps=5
m721 gnd 1990 4438 3487 n l=0.54 w=1.5 ad=0.75 pd=2.5 as=1.35 ps=4.8
m722 4464 2974 gnd 3487 n l=0.54 w=1.5 ad=1.35 pd=4.8 as=0.75 ps=2.5
m723 gnd 2006 4464 3487 n l=0.54 w=1.5 ad=0.75 pd=2.5 as=1.5 ps=5
m724 4465 2008 gnd 3487 n l=0.54 w=1.5 ad=0.75 pd=2.5 as=1.5 ps=5
m725 gnd 2010 4465 3487 n l=0.54 w=1.5 ad=0.75 pd=2.5 as=1.5 ps=5
m726 4466 2012 gnd 3487 n l=0.54 w=1.5 ad=0.75 pd=2.5 as=1.5 ps=5
m727 gnd 2030 4466 3487 n l=0.54 w=1.5 ad=0.75 pd=2.5 as=1.35 ps=4.8
m728 4492 2975 gnd 3487 n l=0.54 w=1.5 ad=1.35 pd=4.8 as=0.75 ps=2.5
m729 gnd 2046 4492 3487 n l=0.54 w=1.5 ad=0.75 pd=2.5 as=1.5 ps=5
m730 4493 2048 gnd 3487 n l=0.54 w=1.5 ad=0.75 pd=2.5 as=1.5 ps=5
m731 gnd 2050 4493 3487 n l=0.54 w=1.5 ad=0.75 pd=2.5 as=1.5 ps=5
m732 4494 2052 gnd 3487 n l=0.54 w=1.5 ad=0.75 pd=2.5 as=1.5 ps=5
m733 gnd 2070 4494 3487 n l=0.54 w=1.5 ad=0.75 pd=2.5 as=1.35 ps=4.8
m734 4520 2976 gnd 3487 n l=0.54 w=1.5 ad=1.35 pd=4.8 as=0.75 ps=2.5
m735 gnd 2086 4520 3487 n l=0.54 w=1.5 ad=0.75 pd=2.5 as=1.5 ps=5
m736 4521 2088 gnd 3487 n l=0.54 w=1.5 ad=0.75 pd=2.5 as=1.5 ps=5
m737 gnd 2090 4521 3487 n l=0.54 w=1.5 ad=0.75 pd=2.5 as=1.5 ps=5
m738 4522 2092 gnd 3487 n l=0.54 w=1.5 ad=0.75 pd=2.5 as=1.5 ps=5
m739 gnd 2110 4522 3487 n l=0.54 w=1.5 ad=0.75 pd=2.5 as=1.35 ps=4.8
m740 4548 2979 gnd 3487 n l=0.54 w=1.5 ad=1.35 pd=4.8 as=0.75 ps=2.5
m741 gnd 2126 4548 3487 n l=0.54 w=1.5 ad=0.75 pd=2.5 as=1.5 ps=5
m742 4549 2128 gnd 3487 n l=0.54 w=1.5 ad=0.75 pd=2.5 as=1.5 ps=5
m743 gnd 2130 4549 3487 n l=0.54 w=1.5 ad=0.75 pd=2.5 as=1.5 ps=5
m744 4550 2132 gnd 3487 n l=0.54 w=1.5 ad=0.75 pd=2.5 as=1.5 ps=5
m745 gnd 2150 4550 3487 n l=0.54 w=1.5 ad=0.75 pd=2.5 as=1.35 ps=4.8
m746 4576 2980 gnd 3487 n l=0.54 w=1.5 ad=1.35 pd=4.8 as=0.75 ps=2.5
m747 gnd 2166 4576 3487 n l=0.54 w=1.5 ad=0.75 pd=2.5 as=1.5 ps=5
m748 4577 2168 gnd 3487 n l=0.54 w=1.5 ad=0.75 pd=2.5 as=1.5 ps=5
m749 gnd 2170 4577 3487 n l=0.54 w=1.5 ad=0.75 pd=2.5 as=1.5 ps=5
m750 4578 2172 gnd 3487 n l=0.54 w=1.5 ad=0.75 pd=2.5 as=1.5 ps=5
m751 gnd 2190 4578 3487 n l=0.54 w=1.5 ad=0.75 pd=2.5 as=1.35 ps=4.8
m752 4604 2981 gnd 3487 n l=0.54 w=1.5 ad=1.35 pd=4.8 as=0.75 ps=2.5
m753 gnd 2206 4604 3487 n l=0.54 w=1.5 ad=0.75 pd=2.5 as=1.5 ps=5
m754 4605 2208 gnd 3487 n l=0.54 w=1.5 ad=0.75 pd=2.5 as=1.5 ps=5
m755 gnd 2210 4605 3487 n l=0.54 w=1.5 ad=0.75 pd=2.5 as=1.5 ps=5
m756 4606 2212 gnd 3487 n l=0.54 w=1.5 ad=0.75 pd=2.5 as=1.5 ps=5
m757 gnd 2230 4606 3487 n l=0.54 w=1.5 ad=0.75 pd=2.5 as=1.35 ps=4.8
m758 4632 2982 gnd 3487 n l=0.54 w=1.5 ad=1.35 pd=4.8 as=0.75 ps=2.5
m759 gnd 2246 4632 3487 n l=0.54 w=1.5 ad=0.75 pd=2.5 as=1.5 ps=5
m760 4633 2248 gnd 3487 n l=0.54 w=1.5 ad=0.75 pd=2.5 as=1.5 ps=5
m761 gnd 2250 4633 3487 n l=0.54 w=1.5 ad=0.75 pd=2.5 as=1.5 ps=5
m762 4634 2252 gnd 3487 n l=0.54 w=1.5 ad=0.75 pd=2.5 as=1.5 ps=5
m763 gnd 2270 4634 3487 n l=0.54 w=1.5 ad=0.75 pd=2.5 as=1.35 ps=4.8
m764 4660 2984 gnd 3487 n l=0.54 w=1.5 ad=1.35 pd=4.8 as=0.75 ps=2.5
m765 gnd 2286 4660 3487 n l=0.54 w=1.5 ad=0.75 pd=2.5 as=1.5 ps=5
m766 4661 2288 gnd 3487 n l=0.54 w=1.5 ad=0.75 pd=2.5 as=1.5 ps=5
m767 gnd 2290 4661 3487 n l=0.54 w=1.5 ad=0.75 pd=2.5 as=1.5 ps=5
m768 4662 2292 gnd 3487 n l=0.54 w=1.5 ad=0.75 pd=2.5 as=1.5 ps=5
m769 gnd 2310 4662 3487 n l=0.54 w=1.5 ad=0.75 pd=2.5 as=1.35 ps=4.8
m770 4688 2984 gnd 3487 n l=0.54 w=1.5 ad=1.35 pd=4.8 as=0.75 ps=2.5
m771 gnd 2326 4688 3487 n l=0.54 w=1.5 ad=0.75 pd=2.5 as=1.5 ps=5
m772 4689 2328 gnd 3487 n l=0.54 w=1.5 ad=0.75 pd=2.5 as=1.5 ps=5
m773 gnd 2330 4689 3487 n l=0.54 w=1.5 ad=0.75 pd=2.5 as=1.5 ps=5
m774 4690 2332 gnd 3487 n l=0.54 w=1.5 ad=0.75 pd=2.5 as=1.5 ps=5
m775 gnd 2350 4690 3487 n l=0.54 w=1.5 ad=0.75 pd=2.5 as=1.35 ps=4.8
m776 4717 2985 gnd 3487 n l=0.54 w=1.5 ad=1.35 pd=4.8 as=0.75 ps=2.5
m777 gnd 2366 4717 3487 n l=0.54 w=1.5 ad=0.75 pd=2.5 as=1.5 ps=5
m778 4718 2368 gnd 3487 n l=0.54 w=1.5 ad=0.75 pd=2.5 as=1.5 ps=5
m779 gnd 2370 4718 3487 n l=0.54 w=1.5 ad=0.75 pd=2.5 as=1.5 ps=5
m780 4719 2372 gnd 3487 n l=0.54 w=1.5 ad=0.75 pd=2.5 as=1.5 ps=5
m781 gnd 2390 4719 3487 n l=0.54 w=1.5 ad=0.75 pd=2.5 as=1.35 ps=4.8
m782 4745 2988 gnd 3487 n l=0.54 w=1.5 ad=1.35 pd=4.8 as=0.75 ps=2.5
m783 gnd 2406 4745 3487 n l=0.54 w=1.5 ad=0.75 pd=2.5 as=1.5 ps=5
m784 4746 2408 gnd 3487 n l=0.54 w=1.5 ad=0.75 pd=2.5 as=1.5 ps=5
m785 gnd 2410 4746 3487 n l=0.54 w=1.5 ad=0.75 pd=2.5 as=1.5 ps=5
m786 4747 2412 gnd 3487 n l=0.54 w=1.5 ad=0.75 pd=2.5 as=1.5 ps=5
m787 gnd 2430 4747 3487 n l=0.54 w=1.5 ad=0.75 pd=2.5 as=1.35 ps=4.8
m788 4773 2989 gnd 3487 n l=0.54 w=1.5 ad=1.35 pd=4.8 as=0.75 ps=2.5
m789 gnd 2446 4773 3487 n l=0.54 w=1.5 ad=0.75 pd=2.5 as=1.5 ps=5
m790 4774 2448 gnd 3487 n l=0.54 w=1.5 ad=0.75 pd=2.5 as=1.5 ps=5
m791 gnd 2450 4774 3487 n l=0.54 w=1.5 ad=0.75 pd=2.5 as=1.5 ps=5
m792 4775 2452 gnd 3487 n l=0.54 w=1.5 ad=0.75 pd=2.5 as=1.5 ps=5
m793 gnd 2470 4775 3487 n l=0.54 w=1.5 ad=0.75 pd=2.5 as=1.35 ps=4.8
m794 4801 2990 gnd 3487 n l=0.54 w=1.5 ad=1.35 pd=4.8 as=0.75 ps=2.5
m795 gnd 2486 4801 3487 n l=0.54 w=1.5 ad=0.75 pd=2.5 as=1.5 ps=5
m796 4802 2488 gnd 3487 n l=0.54 w=1.5 ad=0.75 pd=2.5 as=1.5 ps=5
m797 gnd 2490 4802 3487 n l=0.54 w=1.5 ad=0.75 pd=2.5 as=1.5 ps=5
m798 4803 2492 gnd 3487 n l=0.54 w=1.5 ad=0.75 pd=2.5 as=1.5 ps=5
m799 gnd 2510 4803 3487 n l=0.54 w=1.5 ad=0.75 pd=2.5 as=1.35 ps=4.8
m800 4829 2991 gnd 3487 n l=0.54 w=1.5 ad=1.35 pd=4.8 as=0.75 ps=2.5
m801 gnd 2526 4829 3487 n l=0.54 w=1.5 ad=0.75 pd=2.5 as=1.5 ps=5
m802 4830 2528 gnd 3487 n l=0.54 w=1.5 ad=0.75 pd=2.5 as=1.5 ps=5
m803 gnd 2530 4830 3487 n l=0.54 w=1.5 ad=0.75 pd=2.5 as=1.5 ps=5
m804 4831 2532 gnd 3487 n l=0.54 w=1.5 ad=0.75 pd=2.5 as=1.5 ps=5
m805 gnd 2550 4831 3487 n l=0.54 w=1.5 ad=0.75 pd=2.5 as=1.35 ps=4.8
m806 4857 2992 gnd 3487 n l=0.54 w=1.5 ad=1.35 pd=4.8 as=0.75 ps=2.5
m807 gnd 2566 4857 3487 n l=0.54 w=1.5 ad=0.75 pd=2.5 as=1.5 ps=5
m808 4858 2568 gnd 3487 n l=0.54 w=1.5 ad=0.75 pd=2.5 as=1.5 ps=5
m809 gnd 2570 4858 3487 n l=0.54 w=1.5 ad=0.75 pd=2.5 as=1.5 ps=5
m810 4859 2572 gnd 3487 n l=0.54 w=1.5 ad=0.75 pd=2.5 as=1.5 ps=5
m811 gnd 2590 4859 3487 n l=0.54 w=1.5 ad=0.75 pd=2.5 as=1.35 ps=4.8
m812 4885 2995 gnd 3487 n l=0.54 w=1.5 ad=1.35 pd=4.8 as=0.75 ps=2.5
m813 gnd 2606 4885 3487 n l=0.54 w=1.5 ad=0.75 pd=2.5 as=1.5 ps=5
m814 4886 2608 gnd 3487 n l=0.54 w=1.5 ad=0.75 pd=2.5 as=1.5 ps=5
m815 gnd 2610 4886 3487 n l=0.54 w=1.5 ad=0.75 pd=2.5 as=1.5 ps=5
m816 4887 2612 gnd 3487 n l=0.54 w=1.5 ad=0.75 pd=2.5 as=1.5 ps=5
m817 gnd 2630 4887 3487 n l=0.54 w=1.5 ad=0.75 pd=2.5 as=1.35 ps=4.8
m818 4913 2995 gnd 3487 n l=0.54 w=1.5 ad=1.35 pd=4.8 as=0.75 ps=2.5
m819 gnd 2646 4913 3487 n l=0.54 w=1.5 ad=0.75 pd=2.5 as=1.5 ps=5
m820 4914 2648 gnd 3487 n l=0.54 w=1.5 ad=0.75 pd=2.5 as=1.5 ps=5
m821 gnd 2650 4914 3487 n l=0.54 w=1.5 ad=0.75 pd=2.5 as=1.5 ps=5
m822 4915 2652 gnd 3487 n l=0.54 w=1.5 ad=0.75 pd=2.5 as=1.5 ps=5
m823 gnd 2670 4915 3487 n l=0.54 w=1.5 ad=0.75 pd=2.5 as=1.35 ps=4.8
m824 4941 2996 gnd 3487 n l=0.54 w=1.5 ad=1.35 pd=4.8 as=0.75 ps=2.5
m825 gnd 2686 4941 3487 n l=0.54 w=1.5 ad=0.75 pd=2.5 as=1.5 ps=5
m826 4942 2688 gnd 3487 n l=0.54 w=1.5 ad=0.75 pd=2.5 as=1.5 ps=5
m827 gnd 2690 4942 3487 n l=0.54 w=1.5 ad=0.75 pd=2.5 as=1.5 ps=5
m828 4943 2692 gnd 3487 n l=0.54 w=1.5 ad=0.75 pd=2.5 as=1.5 ps=5
m829 gnd 2710 4943 3487 n l=0.54 w=1.5 ad=0.75 pd=2.5 as=1.35 ps=4.8
m830 4969 2997 gnd 3487 n l=0.54 w=1.5 ad=1.35 pd=4.8 as=0.75 ps=2.5
m831 gnd 2726 4969 3487 n l=0.54 w=1.5 ad=0.75 pd=2.5 as=1.5 ps=5
m832 4970 2728 gnd 3487 n l=0.54 w=1.5 ad=0.75 pd=2.5 as=1.5 ps=5
m833 gnd 2730 4970 3487 n l=0.54 w=1.5 ad=0.75 pd=2.5 as=1.5 ps=5
m834 4971 2732 gnd 3487 n l=0.54 w=1.5 ad=0.75 pd=2.5 as=1.5 ps=5
m835 gnd 2750 4971 3487 n l=0.54 w=1.5 ad=0.75 pd=2.5 as=1.35 ps=4.8
.options post probe=0
.option scale=1u
.global VDD GND gnd vdd
vdd vdd 0 5v
vin1 in1 0 pulse 0 5v 5n 0.1n 0.1n 25n 50n
.meas tran tO69r trig v(in1) val=2.5 rise=3
+ targ v(O69) val=2.5 rise=3
.meas tran tO69f trig v(in1) val=2.5 fall=2
+ targ v(O69) val=2.5 fall=2
.lib 'mod078/mod078.lib' TT
.tran 0.1n 200n
.print(V(O69))
.end
