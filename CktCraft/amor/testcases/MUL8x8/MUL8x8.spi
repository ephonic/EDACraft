*.circuit MUL8x8

*.FLATTENED
* Special Nodes :
* GND 46
* P<7> 16
* B<7> 15
* P<6> 14
* B<6> 13
* P<5> 12
* B<5> 11
* P<4> 10
* B<4> 9
* P<3> 8
* B<3> 7
* P<2> 6
* B<2> 5
* P<1> 4
* B<1> 3
* P<0> 2
* B<0> 1
* VDD 18
* P<8> 244
* P<10> 175
* P<9> 209
* P<12> 107
* P<11> 141
* P<15> 71
* P<13> 73
* P<14> 37
* OVR 17
* A<3> 184
* A<4> 157
* A<5> 131
* A<6> 97
* A<7> 62
* A<2> 217
* A<1> 243
* A<0> 268
*
M0 OVR 35 VDD VDD MP L=0.5 W=1.8 AD=3.51 PD=9.3 AS=1.26 PS=3.2
M1 VDD 269 OVR VDD MP L=0.5 W=1.8 AD=1.26 PD=3.2 AS=4.5 PS=10.4
M2 807 P<14> VDD VDD MP L=0.5 W=1.8 AD=2.25 PD=5.2 AS=0.99 PS=4.7
M3 808 P<15> 807 VDD MP L=0.5 W=1.8 AD=0.495 PD=2.35 AS=1.35 PS=5.1
M4 809 P<13> 808 VDD MP L=0.5 W=1.8 AD=0.675 PD=2.55 AS=2.25 PS=6.1
M5 269 P<12> 809 VDD MP L=0.5 W=1.8 AD=1.125 PD=3.05 AS=1.89 PS=5.7
M6 VDD 278 19 VDD MP L=0.5 W=1.8 AD=1.89 PD=5.7 AS=1.125 PS=3.05
M7 VDD B<1> 270 VDD MP L=0.5 W=1.8 AD=1.89 PD=5.7 AS=1.125 PS=3.05
M8 VDD 279 20 VDD MP L=0.5 W=1.8 AD=1.89 PD=5.7 AS=1.125 PS=3.05
M9 VDD B<2> 271 VDD MP L=0.5 W=1.8 AD=1.89 PD=5.7 AS=1.125 PS=3.05
M10 VDD 280 21 VDD MP L=0.5 W=1.8 AD=1.89 PD=5.7 AS=1.125 PS=3.05
M11 VDD B<3> 272 VDD MP L=0.5 W=1.8 AD=1.89 PD=5.7 AS=1.125 PS=3.05
M12 VDD 281 22 VDD MP L=0.5 W=1.8 AD=1.89 PD=5.7 AS=1.125 PS=3.05
M13 VDD B<4> 273 VDD MP L=0.5 W=1.8 AD=1.89 PD=5.7 AS=1.125 PS=3.05
M14 VDD 282 23 VDD MP L=0.5 W=1.8 AD=1.89 PD=5.7 AS=1.125 PS=3.05
M15 VDD B<5> 274 VDD MP L=0.5 W=1.8 AD=1.89 PD=5.7 AS=1.125 PS=3.05
M16 VDD 283 24 VDD MP L=0.5 W=1.8 AD=1.89 PD=5.7 AS=1.125 PS=3.05
M17 VDD B<6> 275 VDD MP L=0.5 W=1.8 AD=1.89 PD=5.7 AS=1.125 PS=3.05
M18 VDD 284 25 VDD MP L=0.5 W=1.8 AD=1.89 PD=5.7 AS=1.125 PS=3.05
M19 VDD B<7> 276 VDD MP L=0.5 W=1.8 AD=1.89 PD=5.7 AS=1.125 PS=3.05
M20 VDD 285 26 VDD MP L=0.5 W=1.8 AD=1.89 PD=5.7 AS=1.125 PS=3.05
M21 810 P<11> 35 VDD MP L=0.5 W=1.8 AD=1.89 PD=5.7 AS=0.495 PS=2.35
M22 VDD B<0> 277 VDD MP L=0.5 W=1.8 AD=1.98 PD=5.8 AS=1.125 PS=3.05
M23 278 27 VDD VDD MP L=0.5 W=1.8 AD=1.125 PD=3.05 AS=2.25 PS=6.1
M24 28 270 VDD VDD MP L=0.5 W=1.8 AD=1.125 PD=3.05 AS=2.25 PS=6.1
M25 279 28 VDD VDD MP L=0.5 W=1.8 AD=1.125 PD=3.05 AS=2.25 PS=6.1
M26 29 271 VDD VDD MP L=0.5 W=1.8 AD=1.125 PD=3.05 AS=2.25 PS=6.1
M27 280 29 VDD VDD MP L=0.5 W=1.8 AD=1.125 PD=3.05 AS=2.25 PS=6.1
M28 30 272 VDD VDD MP L=0.5 W=1.8 AD=1.125 PD=3.05 AS=2.25 PS=6.1
M29 281 30 VDD VDD MP L=0.5 W=1.8 AD=1.125 PD=3.05 AS=2.25 PS=6.1
M30 31 273 VDD VDD MP L=0.5 W=1.8 AD=1.125 PD=3.05 AS=2.25 PS=6.1
M31 282 31 VDD VDD MP L=0.5 W=1.8 AD=1.125 PD=3.05 AS=2.25 PS=6.1
M32 32 274 VDD VDD MP L=0.5 W=1.8 AD=1.125 PD=3.05 AS=2.25 PS=6.1
M33 283 32 VDD VDD MP L=0.5 W=1.8 AD=1.125 PD=3.05 AS=2.25 PS=6.1
M34 33 275 VDD VDD MP L=0.5 W=1.8 AD=1.125 PD=3.05 AS=2.25 PS=6.1
M35 284 33 VDD VDD MP L=0.5 W=1.8 AD=1.125 PD=3.05 AS=2.25 PS=6.1
M36 34 276 VDD VDD MP L=0.5 W=1.8 AD=1.125 PD=3.05 AS=2.25 PS=6.1
M37 285 34 VDD VDD MP L=0.5 W=1.8 AD=1.125 PD=3.05 AS=2.25 PS=6.1
M38 811 P<10> 810 VDD MP L=0.5 W=1.8 AD=0.495 PD=2.35 AS=0.99 PS=4.7
M39 27 277 VDD VDD MP L=0.5 W=1.8 AD=1.125 PD=3.05 AS=2.25 PS=6.1
M40 VDD 36 278 VDD MP L=0.5 W=1.8 AD=1.125 PD=3.05 AS=1.98 PS=5.8
M41 VDD 270 28 VDD MP L=0.5 W=1.8 AD=1.125 PD=3.05 AS=1.98 PS=5.8
M42 VDD 36 279 VDD MP L=0.5 W=1.8 AD=1.125 PD=3.05 AS=1.98 PS=5.8
M43 VDD 271 29 VDD MP L=0.5 W=1.8 AD=1.125 PD=3.05 AS=1.98 PS=5.8
M44 VDD 36 280 VDD MP L=0.5 W=1.8 AD=1.125 PD=3.05 AS=1.98 PS=5.8
M45 VDD 272 30 VDD MP L=0.5 W=1.8 AD=1.125 PD=3.05 AS=1.98 PS=5.8
M46 VDD 36 281 VDD MP L=0.5 W=1.8 AD=1.125 PD=3.05 AS=1.98 PS=5.8
M47 VDD 273 31 VDD MP L=0.5 W=1.8 AD=1.125 PD=3.05 AS=1.98 PS=5.8
M48 VDD 36 282 VDD MP L=0.5 W=1.8 AD=1.125 PD=3.05 AS=1.98 PS=5.8
M49 VDD 274 32 VDD MP L=0.5 W=1.8 AD=1.125 PD=3.05 AS=1.98 PS=5.8
M50 VDD 36 283 VDD MP L=0.5 W=1.8 AD=1.125 PD=3.05 AS=1.98 PS=5.8
M51 VDD 275 33 VDD MP L=0.5 W=1.8 AD=1.125 PD=3.05 AS=1.98 PS=5.8
M52 VDD 36 284 VDD MP L=0.5 W=1.8 AD=1.125 PD=3.05 AS=1.98 PS=5.8
M53 VDD 276 34 VDD MP L=0.5 W=1.8 AD=1.125 PD=3.05 AS=1.98 PS=5.8
M54 VDD 36 285 VDD MP L=0.5 W=1.8 AD=1.125 PD=3.05 AS=1.98 PS=5.8
M55 812 P<9> 811 VDD MP L=0.5 W=1.8 AD=0.495 PD=2.35 AS=0.99 PS=4.7
M56 VDD 277 27 VDD MP L=0.5 W=1.8 AD=1.125 PD=3.05 AS=1.89 PS=5.7
M57 VDD P<8> 812 VDD MP L=0.5 W=1.8 AD=0.495 PD=2.35 AS=3.51 PS=9.3
M58 813 19 VDD VDD MP L=0.5 W=1.8 AD=2.7 PD=7.5 AS=0.495 PS=2.35
M59 814 20 VDD VDD MP L=0.5 W=1.8 AD=2.7 PD=7.5 AS=0.495 PS=2.35
M60 815 21 VDD VDD MP L=0.5 W=1.8 AD=2.7 PD=7.5 AS=0.495 PS=2.35
M61 816 22 VDD VDD MP L=0.5 W=1.8 AD=2.7 PD=7.5 AS=0.495 PS=2.35
M62 817 23 VDD VDD MP L=0.5 W=1.8 AD=2.7 PD=7.5 AS=0.495 PS=2.35
M63 818 24 VDD VDD MP L=0.5 W=1.8 AD=2.7 PD=7.5 AS=0.495 PS=2.35
M64 819 25 VDD VDD MP L=0.5 W=1.8 AD=2.7 PD=7.5 AS=0.495 PS=2.35
M65 820 26 VDD VDD MP L=0.5 W=1.8 AD=2.7 PD=7.5 AS=0.495 PS=2.35
M66 286 294 38 VDD MP L=0.5 W=1.8 AD=1.89 PD=5.7 AS=1.125 PS=3.05
M67 287 295 39 VDD MP L=0.5 W=1.8 AD=1.89 PD=5.7 AS=1.125 PS=3.05
M68 288 296 40 VDD MP L=0.5 W=1.8 AD=1.89 PD=5.7 AS=1.125 PS=3.05
M69 289 297 41 VDD MP L=0.5 W=1.8 AD=1.89 PD=5.7 AS=1.125 PS=3.05
M70 290 298 42 VDD MP L=0.5 W=1.8 AD=1.89 PD=5.7 AS=1.125 PS=3.05
M71 291 299 43 VDD MP L=0.5 W=1.8 AD=1.89 PD=5.7 AS=1.125 PS=3.05
M72 292 300 44 VDD MP L=0.5 W=1.8 AD=1.89 PD=5.7 AS=1.125 PS=3.05
M73 293 301 P<14> VDD MP L=0.5 W=1.8 AD=1.89 PD=5.7 AS=1.125 PS=3.05
M74 302 54 813 VDD MP L=0.5 W=1.8 AD=0.495 PD=2.35 AS=1.89 PS=5.7
M75 303 55 814 VDD MP L=0.5 W=1.8 AD=0.495 PD=2.35 AS=1.89 PS=5.7
M76 304 56 815 VDD MP L=0.5 W=1.8 AD=0.495 PD=2.35 AS=1.89 PS=5.7
M77 305 57 816 VDD MP L=0.5 W=1.8 AD=0.495 PD=2.35 AS=1.89 PS=5.7
M78 306 58 817 VDD MP L=0.5 W=1.8 AD=0.495 PD=2.35 AS=1.89 PS=5.7
M79 307 59 818 VDD MP L=0.5 W=1.8 AD=0.495 PD=2.35 AS=1.89 PS=5.7
M80 308 60 819 VDD MP L=0.5 W=1.8 AD=0.495 PD=2.35 AS=1.89 PS=5.7
M81 309 61 820 VDD MP L=0.5 W=1.8 AD=0.495 PD=2.35 AS=1.89 PS=5.7
M82 VDD 63 286 VDD MP L=0.5 W=1.8 AD=1.125 PD=3.05 AS=3.06 PS=7.9
M83 VDD 64 287 VDD MP L=0.5 W=1.8 AD=1.125 PD=3.05 AS=3.06 PS=7.9
M84 VDD 65 288 VDD MP L=0.5 W=1.8 AD=1.125 PD=3.05 AS=3.06 PS=7.9
M85 VDD 66 289 VDD MP L=0.5 W=1.8 AD=1.125 PD=3.05 AS=3.06 PS=7.9
M86 VDD 67 290 VDD MP L=0.5 W=1.8 AD=1.125 PD=3.05 AS=3.06 PS=7.9
M87 VDD 68 291 VDD MP L=0.5 W=1.8 AD=1.125 PD=3.05 AS=3.06 PS=7.9
M88 VDD 69 292 VDD MP L=0.5 W=1.8 AD=1.125 PD=3.05 AS=3.06 PS=7.9
M89 VDD 70 293 VDD MP L=0.5 W=1.8 AD=1.125 PD=3.05 AS=3.06 PS=7.9
M90 36 318 VDD VDD MP L=0.5 W=1.8 AD=1.98 PD=5.8 AS=1.125 PS=3.05
M91 286 GND VDD VDD MP L=0.5 W=1.8 AD=1.53 PD=3.95 AS=1.89 PS=5.7
M92 287 47 VDD VDD MP L=0.5 W=1.8 AD=1.53 PD=3.95 AS=1.89 PS=5.7
M93 288 48 VDD VDD MP L=0.5 W=1.8 AD=1.53 PD=3.95 AS=1.89 PS=5.7
M94 289 49 VDD VDD MP L=0.5 W=1.8 AD=1.53 PD=3.95 AS=1.89 PS=5.7
M95 290 50 VDD VDD MP L=0.5 W=1.8 AD=1.53 PD=3.95 AS=1.89 PS=5.7
M96 291 51 VDD VDD MP L=0.5 W=1.8 AD=1.53 PD=3.95 AS=1.89 PS=5.7
M97 292 52 VDD VDD MP L=0.5 W=1.8 AD=1.53 PD=3.95 AS=1.89 PS=5.7
M98 293 53 VDD VDD MP L=0.5 W=1.8 AD=1.53 PD=3.95 AS=1.89 PS=5.7
M99 VDD 318 36 VDD MP L=0.5 W=1.8 AD=1.125 PD=3.05 AS=2.25 PS=6.1
M100 VDD 54 310 VDD MP L=0.5 W=1.8 AD=1.89 PD=5.7 AS=1.53 PS=3.95
M101 VDD 55 311 VDD MP L=0.5 W=1.8 AD=1.89 PD=5.7 AS=1.53 PS=3.95
M102 VDD 56 312 VDD MP L=0.5 W=1.8 AD=1.89 PD=5.7 AS=1.53 PS=5.75
M103 VDD 57 313 VDD MP L=0.5 W=1.8 AD=1.89 PD=5.7 AS=1.53 PS=3.95
M104 VDD 58 314 VDD MP L=0.5 W=1.8 AD=1.89 PD=5.7 AS=1.53 PS=3.95
M105 VDD 59 315 VDD MP L=0.5 W=1.8 AD=1.89 PD=5.7 AS=1.53 PS=3.95
M106 VDD 60 316 VDD MP L=0.5 W=1.8 AD=1.89 PD=5.7 AS=1.53 PS=3.95
M107 VDD 61 317 VDD MP L=0.5 W=1.8 AD=1.89 PD=5.7 AS=1.53 PS=5.75
M108 318 A<7> VDD VDD MP L=0.5 W=1.8 AD=1.125 PD=3.05 AS=1.98 PS=5.8
M109 821 GND 294 VDD MP L=0.5 W=1.8 AD=1.89 PD=5.7 AS=0.495 PS=2.35
M110 822 47 295 VDD MP L=0.5 W=1.8 AD=1.89 PD=5.7 AS=0.495 PS=2.35
M111 823 48 296 VDD MP L=0.5 W=1.8 AD=1.89 PD=5.7 AS=0.495 PS=2.35
M112 824 49 297 VDD MP L=0.5 W=1.8 AD=1.89 PD=5.7 AS=0.495 PS=2.35
M113 825 50 298 VDD MP L=0.5 W=1.8 AD=1.89 PD=5.7 AS=0.495 PS=2.35
M114 826 51 299 VDD MP L=0.5 W=1.8 AD=1.89 PD=5.7 AS=0.495 PS=2.35
M115 827 52 300 VDD MP L=0.5 W=1.8 AD=1.89 PD=5.7 AS=0.495 PS=2.35
M116 828 53 301 VDD MP L=0.5 W=1.8 AD=1.89 PD=5.7 AS=0.495 PS=2.35
M117 310 19 VDD VDD MP L=0.5 W=1.8 AD=1.53 PD=3.95 AS=2.25 PS=6.1
M118 311 20 VDD VDD MP L=0.5 W=1.8 AD=1.53 PD=3.95 AS=2.25 PS=6.1
M119 312 21 VDD VDD MP L=0.5 W=1.8 AD=1.53 PD=5.75 AS=2.25 PS=6.1
M120 313 22 VDD VDD MP L=0.5 W=1.8 AD=1.53 PD=3.95 AS=2.25 PS=6.1
M121 314 23 VDD VDD MP L=0.5 W=1.8 AD=1.53 PD=3.95 AS=2.25 PS=6.1
M122 315 24 VDD VDD MP L=0.5 W=1.8 AD=1.53 PD=3.95 AS=2.25 PS=6.1
M123 316 25 VDD VDD MP L=0.5 W=1.8 AD=1.53 PD=3.95 AS=2.25 PS=6.1
M124 317 26 VDD VDD MP L=0.5 W=1.8 AD=1.53 PD=5.75 AS=2.25 PS=6.1
M125 VDD 63 821 VDD MP L=0.5 W=1.8 AD=0.495 PD=2.35 AS=2.7 PS=7.5
M126 VDD 64 822 VDD MP L=0.5 W=1.8 AD=0.495 PD=2.35 AS=2.7 PS=7.5
M127 VDD 65 823 VDD MP L=0.5 W=1.8 AD=0.495 PD=2.35 AS=2.7 PS=7.5
M128 VDD 66 824 VDD MP L=0.5 W=1.8 AD=0.495 PD=2.35 AS=2.7 PS=7.5
M129 VDD 67 825 VDD MP L=0.5 W=1.8 AD=0.495 PD=2.35 AS=2.7 PS=7.5
M130 VDD 68 826 VDD MP L=0.5 W=1.8 AD=0.495 PD=2.35 AS=2.7 PS=7.5
M131 VDD 69 827 VDD MP L=0.5 W=1.8 AD=0.495 PD=2.35 AS=2.7 PS=7.5
M132 VDD 70 828 VDD MP L=0.5 W=1.8 AD=0.495 PD=2.35 AS=2.7 PS=7.5
M133 63 302 310 VDD MP L=0.5 W=1.8 AD=1.125 PD=3.05 AS=1.89 PS=5.7
M134 64 303 311 VDD MP L=0.5 W=1.8 AD=1.125 PD=3.05 AS=1.89 PS=5.7
M135 65 304 312 VDD MP L=0.5 W=1.8 AD=1.125 PD=3.05 AS=1.89 PS=5.7
M136 66 305 313 VDD MP L=0.5 W=1.8 AD=1.125 PD=3.05 AS=1.89 PS=5.7
M137 67 306 314 VDD MP L=0.5 W=1.8 AD=1.125 PD=3.05 AS=1.89 PS=5.7
M138 68 307 315 VDD MP L=0.5 W=1.8 AD=1.125 PD=3.05 AS=1.89 PS=5.7
M139 69 308 316 VDD MP L=0.5 W=1.8 AD=1.125 PD=3.05 AS=1.89 PS=5.7
M140 70 309 317 VDD MP L=0.5 W=1.8 AD=1.125 PD=3.05 AS=1.89 PS=5.7
M141 319 63 VDD VDD MP L=0.5 W=1.8 AD=1.98 PD=5.8 AS=1.89 PS=5.7
M142 320 64 VDD VDD MP L=0.5 W=1.8 AD=1.98 PD=5.8 AS=1.89 PS=5.7
M143 321 65 VDD VDD MP L=0.5 W=1.8 AD=1.98 PD=5.8 AS=1.89 PS=5.7
M144 322 66 VDD VDD MP L=0.5 W=1.8 AD=1.98 PD=5.8 AS=1.89 PS=5.7
M145 323 67 VDD VDD MP L=0.5 W=1.8 AD=1.98 PD=5.8 AS=1.89 PS=5.7
M146 324 68 VDD VDD MP L=0.5 W=1.8 AD=1.98 PD=5.8 AS=1.89 PS=5.7
M147 325 69 VDD VDD MP L=0.5 W=1.8 AD=1.98 PD=5.8 AS=1.89 PS=5.7
M148 326 70 VDD VDD MP L=0.5 W=1.8 AD=1.98 PD=5.8 AS=1.89 PS=5.7
M149 VDD 327 45 VDD MP L=0.5 W=1.8 AD=1.89 PD=5.7 AS=1.125 PS=3.05
M150 VDD 328 54 VDD MP L=0.5 W=1.8 AD=1.89 PD=5.7 AS=1.125 PS=3.05
M151 VDD 329 55 VDD MP L=0.5 W=1.8 AD=1.89 PD=5.7 AS=1.125 PS=3.05
M152 VDD 330 56 VDD MP L=0.5 W=1.8 AD=1.89 PD=5.7 AS=1.125 PS=3.05
M153 VDD 331 57 VDD MP L=0.5 W=1.8 AD=1.89 PD=5.7 AS=1.125 PS=3.05
M154 VDD 332 58 VDD MP L=0.5 W=1.8 AD=1.89 PD=5.7 AS=1.125 PS=3.05
M155 VDD 333 59 VDD MP L=0.5 W=1.8 AD=1.89 PD=5.7 AS=1.125 PS=3.05
M156 VDD 334 60 VDD MP L=0.5 W=1.8 AD=1.89 PD=5.7 AS=1.125 PS=3.05
M157 327 27 VDD VDD MP L=0.5 W=1.8 AD=1.125 PD=3.05 AS=2.25 PS=6.1
M158 328 28 VDD VDD MP L=0.5 W=1.8 AD=1.125 PD=3.05 AS=2.25 PS=6.1
M159 329 29 VDD VDD MP L=0.5 W=1.8 AD=1.125 PD=3.05 AS=2.25 PS=6.1
M160 330 30 VDD VDD MP L=0.5 W=1.8 AD=1.125 PD=3.05 AS=2.25 PS=6.1
M161 331 31 VDD VDD MP L=0.5 W=1.8 AD=1.125 PD=3.05 AS=2.25 PS=6.1
M162 332 32 VDD VDD MP L=0.5 W=1.8 AD=1.125 PD=3.05 AS=2.25 PS=6.1
M163 333 33 VDD VDD MP L=0.5 W=1.8 AD=1.125 PD=3.05 AS=2.25 PS=6.1
M164 334 34 VDD VDD MP L=0.5 W=1.8 AD=1.125 PD=3.05 AS=2.25 PS=6.1
M165 47 63 54 VDD MP L=0.5 W=1.8 AD=1.98 PD=5.8 AS=1.125 PS=3.05
M166 48 64 55 VDD MP L=0.5 W=1.8 AD=1.98 PD=5.8 AS=1.125 PS=3.05
M167 49 65 56 VDD MP L=0.5 W=1.8 AD=1.98 PD=5.8 AS=1.125 PS=3.05
M168 50 66 57 VDD MP L=0.5 W=1.8 AD=1.98 PD=5.8 AS=1.125 PS=3.05
M169 51 67 58 VDD MP L=0.5 W=1.8 AD=1.98 PD=5.8 AS=1.125 PS=3.05
M170 52 68 59 VDD MP L=0.5 W=1.8 AD=1.98 PD=5.8 AS=1.125 PS=3.05
M171 53 69 60 VDD MP L=0.5 W=1.8 AD=1.98 PD=5.8 AS=1.125 PS=3.05
M172 P<15> 70 61 VDD MP L=0.5 W=1.8 AD=1.98 PD=5.8 AS=1.125 PS=3.05
M173 VDD 72 327 VDD MP L=0.5 W=1.8 AD=1.125 PD=3.05 AS=1.98 PS=5.8
M174 GND 319 47 VDD MP L=0.5 W=1.8 AD=1.125 PD=3.05 AS=1.89 PS=5.7
M175 47 320 48 VDD MP L=0.5 W=1.8 AD=1.125 PD=3.05 AS=1.89 PS=5.7
M176 48 321 49 VDD MP L=0.5 W=1.8 AD=1.125 PD=3.05 AS=1.89 PS=5.7
M177 49 322 50 VDD MP L=0.5 W=1.8 AD=1.125 PD=3.05 AS=1.89 PS=5.7
M178 50 323 51 VDD MP L=0.5 W=1.8 AD=1.125 PD=3.05 AS=1.89 PS=5.7
M179 51 324 52 VDD MP L=0.5 W=1.8 AD=1.125 PD=3.05 AS=1.89 PS=5.7
M180 52 325 53 VDD MP L=0.5 W=1.8 AD=1.125 PD=3.05 AS=1.89 PS=5.7
M181 53 326 P<15> VDD MP L=0.5 W=1.8 AD=1.125 PD=3.05 AS=1.89 PS=5.7
M182 VDD 72 328 VDD MP L=0.5 W=1.8 AD=1.125 PD=3.05 AS=1.98 PS=5.8
M183 VDD 72 329 VDD MP L=0.5 W=1.8 AD=1.125 PD=3.05 AS=1.98 PS=5.8
M184 VDD 72 330 VDD MP L=0.5 W=1.8 AD=1.125 PD=3.05 AS=1.98 PS=5.8
M185 VDD 72 331 VDD MP L=0.5 W=1.8 AD=1.125 PD=3.05 AS=1.98 PS=5.8
M186 VDD 72 332 VDD MP L=0.5 W=1.8 AD=1.125 PD=3.05 AS=1.98 PS=5.8
M187 VDD 72 333 VDD MP L=0.5 W=1.8 AD=1.125 PD=3.05 AS=1.98 PS=5.8
M188 VDD 72 334 VDD MP L=0.5 W=1.8 AD=1.125 PD=3.05 AS=1.98 PS=5.8
M189 829 45 VDD VDD MP L=0.5 W=1.8 AD=2.7 PD=7.5 AS=0.495 PS=2.35
M190 830 38 VDD VDD MP L=0.5 W=1.8 AD=2.7 PD=7.5 AS=0.495 PS=2.35
M191 831 39 VDD VDD MP L=0.5 W=1.8 AD=2.7 PD=7.5 AS=0.495 PS=2.35
M192 832 40 VDD VDD MP L=0.5 W=1.8 AD=2.7 PD=7.5 AS=0.495 PS=2.35
M193 833 41 VDD VDD MP L=0.5 W=1.8 AD=2.7 PD=7.5 AS=0.495 PS=2.35
M194 834 42 VDD VDD MP L=0.5 W=1.8 AD=2.7 PD=7.5 AS=0.495 PS=2.35
M195 835 43 VDD VDD MP L=0.5 W=1.8 AD=2.7 PD=7.5 AS=0.495 PS=2.35
M196 836 44 VDD VDD MP L=0.5 W=1.8 AD=2.7 PD=7.5 AS=0.495 PS=2.35
M197 335 343 74 VDD MP L=0.5 W=1.8 AD=1.89 PD=5.7 AS=1.125 PS=3.05
M198 336 344 75 VDD MP L=0.5 W=1.8 AD=1.89 PD=5.7 AS=1.125 PS=3.05
M199 337 345 76 VDD MP L=0.5 W=1.8 AD=1.89 PD=5.7 AS=1.125 PS=3.05
M200 338 346 77 VDD MP L=0.5 W=1.8 AD=1.89 PD=5.7 AS=1.125 PS=3.05
M201 339 347 78 VDD MP L=0.5 W=1.8 AD=1.89 PD=5.7 AS=1.125 PS=3.05
M202 340 348 79 VDD MP L=0.5 W=1.8 AD=1.89 PD=5.7 AS=1.125 PS=3.05
M203 341 349 80 VDD MP L=0.5 W=1.8 AD=1.89 PD=5.7 AS=1.125 PS=3.05
M204 342 350 P<13> VDD MP L=0.5 W=1.8 AD=1.89 PD=5.7 AS=1.125 PS=3.05
M205 72 367 VDD VDD MP L=0.5 W=1.8 AD=1.98 PD=5.8 AS=1.125 PS=3.05
M206 351 90 829 VDD MP L=0.5 W=1.8 AD=0.495 PD=2.35 AS=1.89 PS=5.7
M207 352 91 830 VDD MP L=0.5 W=1.8 AD=0.495 PD=2.35 AS=1.89 PS=5.7
M208 353 92 831 VDD MP L=0.5 W=1.8 AD=0.495 PD=2.35 AS=1.89 PS=5.7
M209 354 93 832 VDD MP L=0.5 W=1.8 AD=0.495 PD=2.35 AS=1.89 PS=5.7
M210 355 94 833 VDD MP L=0.5 W=1.8 AD=0.495 PD=2.35 AS=1.89 PS=5.7
M211 356 95 834 VDD MP L=0.5 W=1.8 AD=0.495 PD=2.35 AS=1.89 PS=5.7
M212 357 96 835 VDD MP L=0.5 W=1.8 AD=0.495 PD=2.35 AS=1.89 PS=5.7
M213 358 89 836 VDD MP L=0.5 W=1.8 AD=0.495 PD=2.35 AS=1.89 PS=5.7
M214 VDD 98 335 VDD MP L=0.5 W=1.8 AD=1.125 PD=3.05 AS=3.06 PS=7.9
M215 VDD 99 336 VDD MP L=0.5 W=1.8 AD=1.125 PD=3.05 AS=3.06 PS=7.9
M216 VDD 100 337 VDD MP L=0.5 W=1.8 AD=1.125 PD=3.05 AS=3.06 PS=7.9
M217 VDD 101 338 VDD MP L=0.5 W=1.8 AD=1.125 PD=3.05 AS=3.06 PS=7.9
M218 VDD 102 339 VDD MP L=0.5 W=1.8 AD=1.125 PD=3.05 AS=3.06 PS=7.9
M219 VDD 103 340 VDD MP L=0.5 W=1.8 AD=1.125 PD=3.05 AS=3.06 PS=7.9
M220 VDD 104 341 VDD MP L=0.5 W=1.8 AD=1.125 PD=3.05 AS=3.06 PS=7.9
M221 VDD 105 342 VDD MP L=0.5 W=1.8 AD=1.125 PD=3.05 AS=3.06 PS=7.9
M222 VDD 367 72 VDD MP L=0.5 W=1.8 AD=1.125 PD=3.05 AS=2.25 PS=6.1
M223 335 GND VDD VDD MP L=0.5 W=1.8 AD=1.53 PD=3.95 AS=1.89 PS=5.7
M224 336 82 VDD VDD MP L=0.5 W=1.8 AD=1.53 PD=3.95 AS=1.89 PS=5.7
M225 337 83 VDD VDD MP L=0.5 W=1.8 AD=1.53 PD=3.95 AS=1.89 PS=5.7
M226 338 84 VDD VDD MP L=0.5 W=1.8 AD=1.53 PD=3.95 AS=1.89 PS=5.7
M227 339 85 VDD VDD MP L=0.5 W=1.8 AD=1.53 PD=3.95 AS=1.89 PS=5.7
M228 340 86 VDD VDD MP L=0.5 W=1.8 AD=1.53 PD=3.95 AS=1.89 PS=5.7
M229 341 87 VDD VDD MP L=0.5 W=1.8 AD=1.53 PD=3.95 AS=1.89 PS=5.7
M230 342 88 VDD VDD MP L=0.5 W=1.8 AD=1.53 PD=3.95 AS=1.89 PS=5.7
M231 367 A<6> VDD VDD MP L=0.5 W=1.8 AD=1.125 PD=3.05 AS=1.98 PS=5.8
M232 VDD 90 359 VDD MP L=0.5 W=1.8 AD=1.89 PD=5.7 AS=1.53 PS=3.95
M233 VDD 91 360 VDD MP L=0.5 W=1.8 AD=1.89 PD=5.7 AS=1.53 PS=3.95
M234 VDD 92 361 VDD MP L=0.5 W=1.8 AD=1.89 PD=5.7 AS=1.53 PS=5.75
M235 VDD 93 362 VDD MP L=0.5 W=1.8 AD=1.89 PD=5.7 AS=1.53 PS=3.95
M236 VDD 94 363 VDD MP L=0.5 W=1.8 AD=1.89 PD=5.7 AS=1.53 PS=3.95
M237 VDD 95 364 VDD MP L=0.5 W=1.8 AD=1.89 PD=5.7 AS=1.53 PS=3.95
M238 VDD 96 365 VDD MP L=0.5 W=1.8 AD=1.89 PD=5.7 AS=1.53 PS=3.95
M239 VDD 89 366 VDD MP L=0.5 W=1.8 AD=1.89 PD=5.7 AS=1.53 PS=5.75
M240 837 GND 343 VDD MP L=0.5 W=1.8 AD=1.89 PD=5.7 AS=0.495 PS=2.35
M241 838 82 344 VDD MP L=0.5 W=1.8 AD=1.89 PD=5.7 AS=0.495 PS=2.35
M242 839 83 345 VDD MP L=0.5 W=1.8 AD=1.89 PD=5.7 AS=0.495 PS=2.35
M243 840 84 346 VDD MP L=0.5 W=1.8 AD=1.89 PD=5.7 AS=0.495 PS=2.35
M244 841 85 347 VDD MP L=0.5 W=1.8 AD=1.89 PD=5.7 AS=0.495 PS=2.35
M245 842 86 348 VDD MP L=0.5 W=1.8 AD=1.89 PD=5.7 AS=0.495 PS=2.35
M246 843 87 349 VDD MP L=0.5 W=1.8 AD=1.89 PD=5.7 AS=0.495 PS=2.35
M247 844 88 350 VDD MP L=0.5 W=1.8 AD=1.89 PD=5.7 AS=0.495 PS=2.35
M248 359 45 VDD VDD MP L=0.5 W=1.8 AD=1.53 PD=3.95 AS=2.25 PS=6.1
M249 360 38 VDD VDD MP L=0.5 W=1.8 AD=1.53 PD=3.95 AS=2.25 PS=6.1
M250 361 39 VDD VDD MP L=0.5 W=1.8 AD=1.53 PD=5.75 AS=2.25 PS=6.1
M251 362 40 VDD VDD MP L=0.5 W=1.8 AD=1.53 PD=3.95 AS=2.25 PS=6.1
M252 363 41 VDD VDD MP L=0.5 W=1.8 AD=1.53 PD=3.95 AS=2.25 PS=6.1
M253 364 42 VDD VDD MP L=0.5 W=1.8 AD=1.53 PD=3.95 AS=2.25 PS=6.1
M254 365 43 VDD VDD MP L=0.5 W=1.8 AD=1.53 PD=3.95 AS=2.25 PS=6.1
M255 366 44 VDD VDD MP L=0.5 W=1.8 AD=1.53 PD=5.75 AS=2.25 PS=6.1
M256 VDD 98 837 VDD MP L=0.5 W=1.8 AD=0.495 PD=2.35 AS=2.7 PS=7.5
M257 VDD 99 838 VDD MP L=0.5 W=1.8 AD=0.495 PD=2.35 AS=2.7 PS=7.5
M258 VDD 100 839 VDD MP L=0.5 W=1.8 AD=0.495 PD=2.35 AS=2.7 PS=7.5
M259 VDD 101 840 VDD MP L=0.5 W=1.8 AD=0.495 PD=2.35 AS=2.7 PS=7.5
M260 VDD 102 841 VDD MP L=0.5 W=1.8 AD=0.495 PD=2.35 AS=2.7 PS=7.5
M261 VDD 103 842 VDD MP L=0.5 W=1.8 AD=0.495 PD=2.35 AS=2.7 PS=7.5
M262 VDD 104 843 VDD MP L=0.5 W=1.8 AD=0.495 PD=2.35 AS=2.7 PS=7.5
M263 VDD 105 844 VDD MP L=0.5 W=1.8 AD=0.495 PD=2.35 AS=2.7 PS=7.5
M264 98 351 359 VDD MP L=0.5 W=1.8 AD=1.125 PD=3.05 AS=1.89 PS=5.7
M265 99 352 360 VDD MP L=0.5 W=1.8 AD=1.125 PD=3.05 AS=1.89 PS=5.7
M266 100 353 361 VDD MP L=0.5 W=1.8 AD=1.125 PD=3.05 AS=1.89 PS=5.7
M267 101 354 362 VDD MP L=0.5 W=1.8 AD=1.125 PD=3.05 AS=1.89 PS=5.7
M268 102 355 363 VDD MP L=0.5 W=1.8 AD=1.125 PD=3.05 AS=1.89 PS=5.7
M269 103 356 364 VDD MP L=0.5 W=1.8 AD=1.125 PD=3.05 AS=1.89 PS=5.7
M270 104 357 365 VDD MP L=0.5 W=1.8 AD=1.125 PD=3.05 AS=1.89 PS=5.7
M271 105 358 366 VDD MP L=0.5 W=1.8 AD=1.125 PD=3.05 AS=1.89 PS=5.7
M272 VDD 376 81 VDD MP L=0.5 W=1.8 AD=1.89 PD=5.7 AS=1.125 PS=3.05
M273 368 98 VDD VDD MP L=0.5 W=1.8 AD=1.98 PD=5.8 AS=1.89 PS=5.7
M274 369 99 VDD VDD MP L=0.5 W=1.8 AD=1.98 PD=5.8 AS=1.89 PS=5.7
M275 370 100 VDD VDD MP L=0.5 W=1.8 AD=1.98 PD=5.8 AS=1.89 PS=5.7
M276 371 101 VDD VDD MP L=0.5 W=1.8 AD=1.98 PD=5.8 AS=1.89 PS=5.7
M277 372 102 VDD VDD MP L=0.5 W=1.8 AD=1.98 PD=5.8 AS=1.89 PS=5.7
M278 373 103 VDD VDD MP L=0.5 W=1.8 AD=1.98 PD=5.8 AS=1.89 PS=5.7
M279 374 104 VDD VDD MP L=0.5 W=1.8 AD=1.98 PD=5.8 AS=1.89 PS=5.7
M280 375 105 VDD VDD MP L=0.5 W=1.8 AD=1.98 PD=5.8 AS=1.89 PS=5.7
M281 376 27 VDD VDD MP L=0.5 W=1.8 AD=1.125 PD=3.05 AS=2.25 PS=6.1
M282 VDD 377 90 VDD MP L=0.5 W=1.8 AD=1.89 PD=5.7 AS=1.125 PS=3.05
M283 VDD 378 91 VDD MP L=0.5 W=1.8 AD=1.89 PD=5.7 AS=1.125 PS=3.05
M284 VDD 379 92 VDD MP L=0.5 W=1.8 AD=1.89 PD=5.7 AS=1.125 PS=3.05
M285 VDD 380 93 VDD MP L=0.5 W=1.8 AD=1.89 PD=5.7 AS=1.125 PS=3.05
M286 VDD 381 94 VDD MP L=0.5 W=1.8 AD=1.89 PD=5.7 AS=1.125 PS=3.05
M287 VDD 382 95 VDD MP L=0.5 W=1.8 AD=1.89 PD=5.7 AS=1.125 PS=3.05
M288 VDD 383 96 VDD MP L=0.5 W=1.8 AD=1.89 PD=5.7 AS=1.125 PS=3.05
M289 VDD 106 376 VDD MP L=0.5 W=1.8 AD=1.125 PD=3.05 AS=1.98 PS=5.8
M290 377 28 VDD VDD MP L=0.5 W=1.8 AD=1.125 PD=3.05 AS=2.25 PS=6.1
M291 378 29 VDD VDD MP L=0.5 W=1.8 AD=1.125 PD=3.05 AS=2.25 PS=6.1
M292 379 30 VDD VDD MP L=0.5 W=1.8 AD=1.125 PD=3.05 AS=2.25 PS=6.1
M293 380 31 VDD VDD MP L=0.5 W=1.8 AD=1.125 PD=3.05 AS=2.25 PS=6.1
M294 381 32 VDD VDD MP L=0.5 W=1.8 AD=1.125 PD=3.05 AS=2.25 PS=6.1
M295 382 33 VDD VDD MP L=0.5 W=1.8 AD=1.125 PD=3.05 AS=2.25 PS=6.1
M296 383 34 VDD VDD MP L=0.5 W=1.8 AD=1.125 PD=3.05 AS=2.25 PS=6.1
M297 82 98 90 VDD MP L=0.5 W=1.8 AD=1.98 PD=5.8 AS=1.125 PS=3.05
M298 83 99 91 VDD MP L=0.5 W=1.8 AD=1.98 PD=5.8 AS=1.125 PS=3.05
M299 84 100 92 VDD MP L=0.5 W=1.8 AD=1.98 PD=5.8 AS=1.125 PS=3.05
M300 85 101 93 VDD MP L=0.5 W=1.8 AD=1.98 PD=5.8 AS=1.125 PS=3.05
M301 86 102 94 VDD MP L=0.5 W=1.8 AD=1.98 PD=5.8 AS=1.125 PS=3.05
M302 87 103 95 VDD MP L=0.5 W=1.8 AD=1.98 PD=5.8 AS=1.125 PS=3.05
M303 88 104 96 VDD MP L=0.5 W=1.8 AD=1.98 PD=5.8 AS=1.125 PS=3.05
M304 61 105 89 VDD MP L=0.5 W=1.8 AD=1.98 PD=5.8 AS=1.125 PS=3.05
M305 GND 368 82 VDD MP L=0.5 W=1.8 AD=1.125 PD=3.05 AS=1.89 PS=5.7
M306 82 369 83 VDD MP L=0.5 W=1.8 AD=1.125 PD=3.05 AS=1.89 PS=5.7
M307 83 370 84 VDD MP L=0.5 W=1.8 AD=1.125 PD=3.05 AS=1.89 PS=5.7
M308 84 371 85 VDD MP L=0.5 W=1.8 AD=1.125 PD=3.05 AS=1.89 PS=5.7
M309 85 372 86 VDD MP L=0.5 W=1.8 AD=1.125 PD=3.05 AS=1.89 PS=5.7
M310 86 373 87 VDD MP L=0.5 W=1.8 AD=1.125 PD=3.05 AS=1.89 PS=5.7
M311 87 374 88 VDD MP L=0.5 W=1.8 AD=1.125 PD=3.05 AS=1.89 PS=5.7
M312 88 375 61 VDD MP L=0.5 W=1.8 AD=1.125 PD=3.05 AS=1.89 PS=5.7
M313 VDD 106 377 VDD MP L=0.5 W=1.8 AD=1.125 PD=3.05 AS=1.98 PS=5.8
M314 VDD 106 378 VDD MP L=0.5 W=1.8 AD=1.125 PD=3.05 AS=1.98 PS=5.8
M315 VDD 106 379 VDD MP L=0.5 W=1.8 AD=1.125 PD=3.05 AS=1.98 PS=5.8
M316 VDD 106 380 VDD MP L=0.5 W=1.8 AD=1.125 PD=3.05 AS=1.98 PS=5.8
M317 VDD 106 381 VDD MP L=0.5 W=1.8 AD=1.125 PD=3.05 AS=1.98 PS=5.8
M318 VDD 106 382 VDD MP L=0.5 W=1.8 AD=1.125 PD=3.05 AS=1.98 PS=5.8
M319 VDD 106 383 VDD MP L=0.5 W=1.8 AD=1.125 PD=3.05 AS=1.98 PS=5.8
M320 106 408 VDD VDD MP L=0.5 W=1.8 AD=1.98 PD=5.8 AS=1.125 PS=3.05
M321 845 81 VDD VDD MP L=0.5 W=1.8 AD=2.7 PD=7.5 AS=0.495 PS=2.35
M322 846 74 VDD VDD MP L=0.5 W=1.8 AD=2.7 PD=7.5 AS=0.495 PS=2.35
M323 847 75 VDD VDD MP L=0.5 W=1.8 AD=2.7 PD=7.5 AS=0.495 PS=2.35
M324 848 76 VDD VDD MP L=0.5 W=1.8 AD=2.7 PD=7.5 AS=0.495 PS=2.35
M325 849 77 VDD VDD MP L=0.5 W=1.8 AD=2.7 PD=7.5 AS=0.495 PS=2.35
M326 850 78 VDD VDD MP L=0.5 W=1.8 AD=2.7 PD=7.5 AS=0.495 PS=2.35
M327 851 79 VDD VDD MP L=0.5 W=1.8 AD=2.7 PD=7.5 AS=0.495 PS=2.35
M328 852 80 VDD VDD MP L=0.5 W=1.8 AD=2.7 PD=7.5 AS=0.495 PS=2.35
M329 384 392 108 VDD MP L=0.5 W=1.8 AD=1.89 PD=5.7 AS=1.125 PS=3.05
M330 385 393 109 VDD MP L=0.5 W=1.8 AD=1.89 PD=5.7 AS=1.125 PS=3.05
M331 386 394 110 VDD MP L=0.5 W=1.8 AD=1.89 PD=5.7 AS=1.125 PS=3.05
M332 387 395 111 VDD MP L=0.5 W=1.8 AD=1.89 PD=5.7 AS=1.125 PS=3.05
M333 388 396 112 VDD MP L=0.5 W=1.8 AD=1.89 PD=5.7 AS=1.125 PS=3.05
M334 389 397 113 VDD MP L=0.5 W=1.8 AD=1.89 PD=5.7 AS=1.125 PS=3.05
M335 390 398 114 VDD MP L=0.5 W=1.8 AD=1.89 PD=5.7 AS=1.125 PS=3.05
M336 391 399 P<12> VDD MP L=0.5 W=1.8 AD=1.89 PD=5.7 AS=1.125 PS=3.05
M337 VDD 408 106 VDD MP L=0.5 W=1.8 AD=1.125 PD=3.05 AS=2.25 PS=6.1
M338 400 123 845 VDD MP L=0.5 W=1.8 AD=0.495 PD=2.35 AS=1.89 PS=5.7
M339 401 124 846 VDD MP L=0.5 W=1.8 AD=0.495 PD=2.35 AS=1.89 PS=5.7
M340 402 125 847 VDD MP L=0.5 W=1.8 AD=0.495 PD=2.35 AS=1.89 PS=5.7
M341 403 126 848 VDD MP L=0.5 W=1.8 AD=0.495 PD=2.35 AS=1.89 PS=5.7
M342 404 127 849 VDD MP L=0.5 W=1.8 AD=0.495 PD=2.35 AS=1.89 PS=5.7
M343 405 128 850 VDD MP L=0.5 W=1.8 AD=0.495 PD=2.35 AS=1.89 PS=5.7
M344 406 129 851 VDD MP L=0.5 W=1.8 AD=0.495 PD=2.35 AS=1.89 PS=5.7
M345 407 130 852 VDD MP L=0.5 W=1.8 AD=0.495 PD=2.35 AS=1.89 PS=5.7
M346 VDD 132 384 VDD MP L=0.5 W=1.8 AD=1.125 PD=3.05 AS=3.06 PS=7.9
M347 VDD 133 385 VDD MP L=0.5 W=1.8 AD=1.125 PD=3.05 AS=3.06 PS=7.9
M348 VDD 134 386 VDD MP L=0.5 W=1.8 AD=1.125 PD=3.05 AS=3.06 PS=7.9
M349 VDD 135 387 VDD MP L=0.5 W=1.8 AD=1.125 PD=3.05 AS=3.06 PS=7.9
M350 VDD 136 388 VDD MP L=0.5 W=1.8 AD=1.125 PD=3.05 AS=3.06 PS=7.9
M351 VDD 137 389 VDD MP L=0.5 W=1.8 AD=1.125 PD=3.05 AS=3.06 PS=7.9
M352 VDD 138 390 VDD MP L=0.5 W=1.8 AD=1.125 PD=3.05 AS=3.06 PS=7.9
M353 VDD 139 391 VDD MP L=0.5 W=1.8 AD=1.125 PD=3.05 AS=3.06 PS=7.9
M354 408 A<5> VDD VDD MP L=0.5 W=1.8 AD=1.125 PD=3.05 AS=1.98 PS=5.8
M355 384 GND VDD VDD MP L=0.5 W=1.8 AD=1.53 PD=3.95 AS=1.89 PS=5.7
M356 385 116 VDD VDD MP L=0.5 W=1.8 AD=1.53 PD=3.95 AS=1.89 PS=5.7
M357 386 117 VDD VDD MP L=0.5 W=1.8 AD=1.53 PD=3.95 AS=1.89 PS=5.7
M358 387 118 VDD VDD MP L=0.5 W=1.8 AD=1.53 PD=3.95 AS=1.89 PS=5.7
M359 388 119 VDD VDD MP L=0.5 W=1.8 AD=1.53 PD=3.95 AS=1.89 PS=5.7
M360 389 120 VDD VDD MP L=0.5 W=1.8 AD=1.53 PD=3.95 AS=1.89 PS=5.7
M361 390 121 VDD VDD MP L=0.5 W=1.8 AD=1.53 PD=3.95 AS=1.89 PS=5.7
M362 391 122 VDD VDD MP L=0.5 W=1.8 AD=1.53 PD=3.95 AS=1.89 PS=5.7
M363 VDD 123 409 VDD MP L=0.5 W=1.8 AD=1.89 PD=5.7 AS=1.53 PS=3.95
M364 VDD 124 410 VDD MP L=0.5 W=1.8 AD=1.89 PD=5.7 AS=1.53 PS=3.95
M365 VDD 125 411 VDD MP L=0.5 W=1.8 AD=1.89 PD=5.7 AS=1.53 PS=5.75
M366 VDD 126 412 VDD MP L=0.5 W=1.8 AD=1.89 PD=5.7 AS=1.53 PS=3.95
M367 VDD 127 413 VDD MP L=0.5 W=1.8 AD=1.89 PD=5.7 AS=1.53 PS=3.95
M368 VDD 128 414 VDD MP L=0.5 W=1.8 AD=1.89 PD=5.7 AS=1.53 PS=3.95
M369 VDD 129 415 VDD MP L=0.5 W=1.8 AD=1.89 PD=5.7 AS=1.53 PS=3.95
M370 VDD 130 416 VDD MP L=0.5 W=1.8 AD=1.89 PD=5.7 AS=1.53 PS=5.75
M371 853 GND 392 VDD MP L=0.5 W=1.8 AD=1.89 PD=5.7 AS=0.495 PS=2.35
M372 854 116 393 VDD MP L=0.5 W=1.8 AD=1.89 PD=5.7 AS=0.495 PS=2.35
M373 855 117 394 VDD MP L=0.5 W=1.8 AD=1.89 PD=5.7 AS=0.495 PS=2.35
M374 856 118 395 VDD MP L=0.5 W=1.8 AD=1.89 PD=5.7 AS=0.495 PS=2.35
M375 857 119 396 VDD MP L=0.5 W=1.8 AD=1.89 PD=5.7 AS=0.495 PS=2.35
M376 858 120 397 VDD MP L=0.5 W=1.8 AD=1.89 PD=5.7 AS=0.495 PS=2.35
M377 859 121 398 VDD MP L=0.5 W=1.8 AD=1.89 PD=5.7 AS=0.495 PS=2.35
M378 860 122 399 VDD MP L=0.5 W=1.8 AD=1.89 PD=5.7 AS=0.495 PS=2.35
M379 409 81 VDD VDD MP L=0.5 W=1.8 AD=1.53 PD=3.95 AS=2.25 PS=6.1
M380 410 74 VDD VDD MP L=0.5 W=1.8 AD=1.53 PD=3.95 AS=2.25 PS=6.1
M381 411 75 VDD VDD MP L=0.5 W=1.8 AD=1.53 PD=5.75 AS=2.25 PS=6.1
M382 412 76 VDD VDD MP L=0.5 W=1.8 AD=1.53 PD=3.95 AS=2.25 PS=6.1
M383 413 77 VDD VDD MP L=0.5 W=1.8 AD=1.53 PD=3.95 AS=2.25 PS=6.1
M384 414 78 VDD VDD MP L=0.5 W=1.8 AD=1.53 PD=3.95 AS=2.25 PS=6.1
M385 415 79 VDD VDD MP L=0.5 W=1.8 AD=1.53 PD=3.95 AS=2.25 PS=6.1
M386 416 80 VDD VDD MP L=0.5 W=1.8 AD=1.53 PD=5.75 AS=2.25 PS=6.1
M387 VDD 132 853 VDD MP L=0.5 W=1.8 AD=0.495 PD=2.35 AS=2.7 PS=7.5
M388 VDD 133 854 VDD MP L=0.5 W=1.8 AD=0.495 PD=2.35 AS=2.7 PS=7.5
M389 VDD 134 855 VDD MP L=0.5 W=1.8 AD=0.495 PD=2.35 AS=2.7 PS=7.5
M390 VDD 135 856 VDD MP L=0.5 W=1.8 AD=0.495 PD=2.35 AS=2.7 PS=7.5
M391 VDD 136 857 VDD MP L=0.5 W=1.8 AD=0.495 PD=2.35 AS=2.7 PS=7.5
M392 VDD 137 858 VDD MP L=0.5 W=1.8 AD=0.495 PD=2.35 AS=2.7 PS=7.5
M393 VDD 138 859 VDD MP L=0.5 W=1.8 AD=0.495 PD=2.35 AS=2.7 PS=7.5
M394 VDD 139 860 VDD MP L=0.5 W=1.8 AD=0.495 PD=2.35 AS=2.7 PS=7.5
M395 132 400 409 VDD MP L=0.5 W=1.8 AD=1.125 PD=3.05 AS=1.89 PS=5.7
M396 133 401 410 VDD MP L=0.5 W=1.8 AD=1.125 PD=3.05 AS=1.89 PS=5.7
M397 134 402 411 VDD MP L=0.5 W=1.8 AD=1.125 PD=3.05 AS=1.89 PS=5.7
M398 135 403 412 VDD MP L=0.5 W=1.8 AD=1.125 PD=3.05 AS=1.89 PS=5.7
M399 136 404 413 VDD MP L=0.5 W=1.8 AD=1.125 PD=3.05 AS=1.89 PS=5.7
M400 137 405 414 VDD MP L=0.5 W=1.8 AD=1.125 PD=3.05 AS=1.89 PS=5.7
M401 138 406 415 VDD MP L=0.5 W=1.8 AD=1.125 PD=3.05 AS=1.89 PS=5.7
M402 139 407 416 VDD MP L=0.5 W=1.8 AD=1.125 PD=3.05 AS=1.89 PS=5.7
M403 VDD 417 115 VDD MP L=0.5 W=1.8 AD=1.89 PD=5.7 AS=1.125 PS=3.05
M404 417 27 VDD VDD MP L=0.5 W=1.8 AD=1.125 PD=3.05 AS=2.25 PS=6.1
M405 418 132 VDD VDD MP L=0.5 W=1.8 AD=1.98 PD=5.8 AS=1.89 PS=5.7
M406 419 133 VDD VDD MP L=0.5 W=1.8 AD=1.98 PD=5.8 AS=1.89 PS=5.7
M407 420 134 VDD VDD MP L=0.5 W=1.8 AD=1.98 PD=5.8 AS=1.89 PS=5.7
M408 421 135 VDD VDD MP L=0.5 W=1.8 AD=1.98 PD=5.8 AS=1.89 PS=5.7
M409 422 136 VDD VDD MP L=0.5 W=1.8 AD=1.98 PD=5.8 AS=1.89 PS=5.7
M410 423 137 VDD VDD MP L=0.5 W=1.8 AD=1.98 PD=5.8 AS=1.89 PS=5.7
M411 424 138 VDD VDD MP L=0.5 W=1.8 AD=1.98 PD=5.8 AS=1.89 PS=5.7
M412 425 139 VDD VDD MP L=0.5 W=1.8 AD=1.98 PD=5.8 AS=1.89 PS=5.7
M413 VDD 140 417 VDD MP L=0.5 W=1.8 AD=1.125 PD=3.05 AS=1.98 PS=5.8
M414 VDD 426 123 VDD MP L=0.5 W=1.8 AD=1.89 PD=5.7 AS=1.125 PS=3.05
M415 VDD 427 124 VDD MP L=0.5 W=1.8 AD=1.89 PD=5.7 AS=1.125 PS=3.05
M416 VDD 428 125 VDD MP L=0.5 W=1.8 AD=1.89 PD=5.7 AS=1.125 PS=3.05
M417 VDD 429 126 VDD MP L=0.5 W=1.8 AD=1.89 PD=5.7 AS=1.125 PS=3.05
M418 VDD 430 127 VDD MP L=0.5 W=1.8 AD=1.89 PD=5.7 AS=1.125 PS=3.05
M419 VDD 431 128 VDD MP L=0.5 W=1.8 AD=1.89 PD=5.7 AS=1.125 PS=3.05
M420 VDD 432 129 VDD MP L=0.5 W=1.8 AD=1.89 PD=5.7 AS=1.125 PS=3.05
M421 426 28 VDD VDD MP L=0.5 W=1.8 AD=1.125 PD=3.05 AS=2.25 PS=6.1
M422 427 29 VDD VDD MP L=0.5 W=1.8 AD=1.125 PD=3.05 AS=2.25 PS=6.1
M423 428 30 VDD VDD MP L=0.5 W=1.8 AD=1.125 PD=3.05 AS=2.25 PS=6.1
M424 429 31 VDD VDD MP L=0.5 W=1.8 AD=1.125 PD=3.05 AS=2.25 PS=6.1
M425 430 32 VDD VDD MP L=0.5 W=1.8 AD=1.125 PD=3.05 AS=2.25 PS=6.1
M426 431 33 VDD VDD MP L=0.5 W=1.8 AD=1.125 PD=3.05 AS=2.25 PS=6.1
M427 432 34 VDD VDD MP L=0.5 W=1.8 AD=1.125 PD=3.05 AS=2.25 PS=6.1
M428 116 132 123 VDD MP L=0.5 W=1.8 AD=1.98 PD=5.8 AS=1.125 PS=3.05
M429 117 133 124 VDD MP L=0.5 W=1.8 AD=1.98 PD=5.8 AS=1.125 PS=3.05
M430 118 134 125 VDD MP L=0.5 W=1.8 AD=1.98 PD=5.8 AS=1.125 PS=3.05
M431 119 135 126 VDD MP L=0.5 W=1.8 AD=1.98 PD=5.8 AS=1.125 PS=3.05
M432 120 136 127 VDD MP L=0.5 W=1.8 AD=1.98 PD=5.8 AS=1.125 PS=3.05
M433 121 137 128 VDD MP L=0.5 W=1.8 AD=1.98 PD=5.8 AS=1.125 PS=3.05
M434 122 138 129 VDD MP L=0.5 W=1.8 AD=1.98 PD=5.8 AS=1.125 PS=3.05
M435 89 139 130 VDD MP L=0.5 W=1.8 AD=1.98 PD=5.8 AS=1.125 PS=3.05
M436 GND 418 116 VDD MP L=0.5 W=1.8 AD=1.125 PD=3.05 AS=1.89 PS=5.7
M437 116 419 117 VDD MP L=0.5 W=1.8 AD=1.125 PD=3.05 AS=1.89 PS=5.7
M438 117 420 118 VDD MP L=0.5 W=1.8 AD=1.125 PD=3.05 AS=1.89 PS=5.7
M439 118 421 119 VDD MP L=0.5 W=1.8 AD=1.125 PD=3.05 AS=1.89 PS=5.7
M440 119 422 120 VDD MP L=0.5 W=1.8 AD=1.125 PD=3.05 AS=1.89 PS=5.7
M441 120 423 121 VDD MP L=0.5 W=1.8 AD=1.125 PD=3.05 AS=1.89 PS=5.7
M442 121 424 122 VDD MP L=0.5 W=1.8 AD=1.125 PD=3.05 AS=1.89 PS=5.7
M443 122 425 89 VDD MP L=0.5 W=1.8 AD=1.125 PD=3.05 AS=1.89 PS=5.7
M444 VDD 140 426 VDD MP L=0.5 W=1.8 AD=1.125 PD=3.05 AS=1.98 PS=5.8
M445 VDD 140 427 VDD MP L=0.5 W=1.8 AD=1.125 PD=3.05 AS=1.98 PS=5.8
M446 VDD 140 428 VDD MP L=0.5 W=1.8 AD=1.125 PD=3.05 AS=1.98 PS=5.8
M447 VDD 140 429 VDD MP L=0.5 W=1.8 AD=1.125 PD=3.05 AS=1.98 PS=5.8
M448 VDD 140 430 VDD MP L=0.5 W=1.8 AD=1.125 PD=3.05 AS=1.98 PS=5.8
M449 VDD 140 431 VDD MP L=0.5 W=1.8 AD=1.125 PD=3.05 AS=1.98 PS=5.8
M450 VDD 140 432 VDD MP L=0.5 W=1.8 AD=1.125 PD=3.05 AS=1.98 PS=5.8
M451 140 433 VDD VDD MP L=0.5 W=1.8 AD=1.98 PD=5.8 AS=1.125 PS=3.05
M452 VDD 433 140 VDD MP L=0.5 W=1.8 AD=1.125 PD=3.05 AS=2.25 PS=6.1
M453 861 115 VDD VDD MP L=0.5 W=1.8 AD=2.7 PD=7.5 AS=0.495 PS=2.35
M454 862 108 VDD VDD MP L=0.5 W=1.8 AD=2.7 PD=7.5 AS=0.495 PS=2.35
M455 863 109 VDD VDD MP L=0.5 W=1.8 AD=2.7 PD=7.5 AS=0.495 PS=2.35
M456 864 110 VDD VDD MP L=0.5 W=1.8 AD=2.7 PD=7.5 AS=0.495 PS=2.35
M457 865 111 VDD VDD MP L=0.5 W=1.8 AD=2.7 PD=7.5 AS=0.495 PS=2.35
M458 866 112 VDD VDD MP L=0.5 W=1.8 AD=2.7 PD=7.5 AS=0.495 PS=2.35
M459 867 113 VDD VDD MP L=0.5 W=1.8 AD=2.7 PD=7.5 AS=0.495 PS=2.35
M460 868 114 VDD VDD MP L=0.5 W=1.8 AD=2.7 PD=7.5 AS=0.495 PS=2.35
M461 434 442 142 VDD MP L=0.5 W=1.8 AD=1.89 PD=5.7 AS=1.125 PS=3.05
M462 435 443 143 VDD MP L=0.5 W=1.8 AD=1.89 PD=5.7 AS=1.125 PS=3.05
M463 436 444 144 VDD MP L=0.5 W=1.8 AD=1.89 PD=5.7 AS=1.125 PS=3.05
M464 437 445 145 VDD MP L=0.5 W=1.8 AD=1.89 PD=5.7 AS=1.125 PS=3.05
M465 438 446 146 VDD MP L=0.5 W=1.8 AD=1.89 PD=5.7 AS=1.125 PS=3.05
M466 439 447 147 VDD MP L=0.5 W=1.8 AD=1.89 PD=5.7 AS=1.125 PS=3.05
M467 440 448 148 VDD MP L=0.5 W=1.8 AD=1.89 PD=5.7 AS=1.125 PS=3.05
M468 441 449 P<11> VDD MP L=0.5 W=1.8 AD=1.89 PD=5.7 AS=1.125 PS=3.05
M469 433 A<4> VDD VDD MP L=0.5 W=1.8 AD=1.125 PD=3.05 AS=1.98 PS=5.8
M470 450 159 861 VDD MP L=0.5 W=1.8 AD=0.495 PD=2.35 AS=1.89 PS=5.7
M471 451 160 862 VDD MP L=0.5 W=1.8 AD=0.495 PD=2.35 AS=1.89 PS=5.7
M472 452 161 863 VDD MP L=0.5 W=1.8 AD=0.495 PD=2.35 AS=1.89 PS=5.7
M473 453 162 864 VDD MP L=0.5 W=1.8 AD=0.495 PD=2.35 AS=1.89 PS=5.7
M474 454 163 865 VDD MP L=0.5 W=1.8 AD=0.495 PD=2.35 AS=1.89 PS=5.7
M475 455 164 866 VDD MP L=0.5 W=1.8 AD=0.495 PD=2.35 AS=1.89 PS=5.7
M476 456 165 867 VDD MP L=0.5 W=1.8 AD=0.495 PD=2.35 AS=1.89 PS=5.7
M477 457 158 868 VDD MP L=0.5 W=1.8 AD=0.495 PD=2.35 AS=1.89 PS=5.7
M478 VDD 166 434 VDD MP L=0.5 W=1.8 AD=1.125 PD=3.05 AS=3.06 PS=7.9
M479 VDD 167 435 VDD MP L=0.5 W=1.8 AD=1.125 PD=3.05 AS=3.06 PS=7.9
M480 VDD 168 436 VDD MP L=0.5 W=1.8 AD=1.125 PD=3.05 AS=3.06 PS=7.9
M481 VDD 169 437 VDD MP L=0.5 W=1.8 AD=1.125 PD=3.05 AS=3.06 PS=7.9
M482 VDD 170 438 VDD MP L=0.5 W=1.8 AD=1.125 PD=3.05 AS=3.06 PS=7.9
M483 VDD 171 439 VDD MP L=0.5 W=1.8 AD=1.125 PD=3.05 AS=3.06 PS=7.9
M484 VDD 172 440 VDD MP L=0.5 W=1.8 AD=1.125 PD=3.05 AS=3.06 PS=7.9
M485 VDD 173 441 VDD MP L=0.5 W=1.8 AD=1.125 PD=3.05 AS=3.06 PS=7.9
M486 434 GND VDD VDD MP L=0.5 W=1.8 AD=1.53 PD=3.95 AS=1.89 PS=5.7
M487 435 150 VDD VDD MP L=0.5 W=1.8 AD=1.53 PD=3.95 AS=1.89 PS=5.7
M488 436 151 VDD VDD MP L=0.5 W=1.8 AD=1.53 PD=3.95 AS=1.89 PS=5.7
M489 437 152 VDD VDD MP L=0.5 W=1.8 AD=1.53 PD=3.95 AS=1.89 PS=5.7
M490 438 153 VDD VDD MP L=0.5 W=1.8 AD=1.53 PD=3.95 AS=1.89 PS=5.7
M491 439 154 VDD VDD MP L=0.5 W=1.8 AD=1.53 PD=3.95 AS=1.89 PS=5.7
M492 440 155 VDD VDD MP L=0.5 W=1.8 AD=1.53 PD=3.95 AS=1.89 PS=5.7
M493 441 156 VDD VDD MP L=0.5 W=1.8 AD=1.53 PD=3.95 AS=1.89 PS=5.7
M494 VDD 159 458 VDD MP L=0.5 W=1.8 AD=1.89 PD=5.7 AS=1.53 PS=3.95
M495 VDD 160 459 VDD MP L=0.5 W=1.8 AD=1.89 PD=5.7 AS=1.53 PS=3.95
M496 VDD 161 460 VDD MP L=0.5 W=1.8 AD=1.89 PD=5.7 AS=1.53 PS=5.75
M497 VDD 162 461 VDD MP L=0.5 W=1.8 AD=1.89 PD=5.7 AS=1.53 PS=3.95
M498 VDD 163 462 VDD MP L=0.5 W=1.8 AD=1.89 PD=5.7 AS=1.53 PS=3.95
M499 VDD 164 463 VDD MP L=0.5 W=1.8 AD=1.89 PD=5.7 AS=1.53 PS=3.95
M500 VDD 165 464 VDD MP L=0.5 W=1.8 AD=1.89 PD=5.7 AS=1.53 PS=3.95
M501 VDD 158 465 VDD MP L=0.5 W=1.8 AD=1.89 PD=5.7 AS=1.53 PS=5.75
M502 869 GND 442 VDD MP L=0.5 W=1.8 AD=1.89 PD=5.7 AS=0.495 PS=2.35
M503 870 150 443 VDD MP L=0.5 W=1.8 AD=1.89 PD=5.7 AS=0.495 PS=2.35
M504 871 151 444 VDD MP L=0.5 W=1.8 AD=1.89 PD=5.7 AS=0.495 PS=2.35
M505 872 152 445 VDD MP L=0.5 W=1.8 AD=1.89 PD=5.7 AS=0.495 PS=2.35
M506 873 153 446 VDD MP L=0.5 W=1.8 AD=1.89 PD=5.7 AS=0.495 PS=2.35
M507 874 154 447 VDD MP L=0.5 W=1.8 AD=1.89 PD=5.7 AS=0.495 PS=2.35
M508 875 155 448 VDD MP L=0.5 W=1.8 AD=1.89 PD=5.7 AS=0.495 PS=2.35
M509 876 156 449 VDD MP L=0.5 W=1.8 AD=1.89 PD=5.7 AS=0.495 PS=2.35
M510 458 115 VDD VDD MP L=0.5 W=1.8 AD=1.53 PD=3.95 AS=2.25 PS=6.1
M511 459 108 VDD VDD MP L=0.5 W=1.8 AD=1.53 PD=3.95 AS=2.25 PS=6.1
M512 460 109 VDD VDD MP L=0.5 W=1.8 AD=1.53 PD=5.75 AS=2.25 PS=6.1
M513 461 110 VDD VDD MP L=0.5 W=1.8 AD=1.53 PD=3.95 AS=2.25 PS=6.1
M514 462 111 VDD VDD MP L=0.5 W=1.8 AD=1.53 PD=3.95 AS=2.25 PS=6.1
M515 463 112 VDD VDD MP L=0.5 W=1.8 AD=1.53 PD=3.95 AS=2.25 PS=6.1
M516 464 113 VDD VDD MP L=0.5 W=1.8 AD=1.53 PD=3.95 AS=2.25 PS=6.1
M517 465 114 VDD VDD MP L=0.5 W=1.8 AD=1.53 PD=5.75 AS=2.25 PS=6.1
M518 VDD 466 149 VDD MP L=0.5 W=1.8 AD=1.89 PD=5.7 AS=1.125 PS=3.05
M519 VDD 166 869 VDD MP L=0.5 W=1.8 AD=0.495 PD=2.35 AS=2.7 PS=7.5
M520 VDD 167 870 VDD MP L=0.5 W=1.8 AD=0.495 PD=2.35 AS=2.7 PS=7.5
M521 VDD 168 871 VDD MP L=0.5 W=1.8 AD=0.495 PD=2.35 AS=2.7 PS=7.5
M522 VDD 169 872 VDD MP L=0.5 W=1.8 AD=0.495 PD=2.35 AS=2.7 PS=7.5
M523 VDD 170 873 VDD MP L=0.5 W=1.8 AD=0.495 PD=2.35 AS=2.7 PS=7.5
M524 VDD 171 874 VDD MP L=0.5 W=1.8 AD=0.495 PD=2.35 AS=2.7 PS=7.5
M525 VDD 172 875 VDD MP L=0.5 W=1.8 AD=0.495 PD=2.35 AS=2.7 PS=7.5
M526 VDD 173 876 VDD MP L=0.5 W=1.8 AD=0.495 PD=2.35 AS=2.7 PS=7.5
M527 166 450 458 VDD MP L=0.5 W=1.8 AD=1.125 PD=3.05 AS=1.89 PS=5.7
M528 167 451 459 VDD MP L=0.5 W=1.8 AD=1.125 PD=3.05 AS=1.89 PS=5.7
M529 168 452 460 VDD MP L=0.5 W=1.8 AD=1.125 PD=3.05 AS=1.89 PS=5.7
M530 169 453 461 VDD MP L=0.5 W=1.8 AD=1.125 PD=3.05 AS=1.89 PS=5.7
M531 170 454 462 VDD MP L=0.5 W=1.8 AD=1.125 PD=3.05 AS=1.89 PS=5.7
M532 171 455 463 VDD MP L=0.5 W=1.8 AD=1.125 PD=3.05 AS=1.89 PS=5.7
M533 172 456 464 VDD MP L=0.5 W=1.8 AD=1.125 PD=3.05 AS=1.89 PS=5.7
M534 173 457 465 VDD MP L=0.5 W=1.8 AD=1.125 PD=3.05 AS=1.89 PS=5.7
M535 466 27 VDD VDD MP L=0.5 W=1.8 AD=1.125 PD=3.05 AS=2.25 PS=6.1
M536 VDD 174 466 VDD MP L=0.5 W=1.8 AD=1.125 PD=3.05 AS=1.98 PS=5.8
M537 467 166 VDD VDD MP L=0.5 W=1.8 AD=1.98 PD=5.8 AS=1.89 PS=5.7
M538 468 167 VDD VDD MP L=0.5 W=1.8 AD=1.98 PD=5.8 AS=1.89 PS=5.7
M539 469 168 VDD VDD MP L=0.5 W=1.8 AD=1.98 PD=5.8 AS=1.89 PS=5.7
M540 470 169 VDD VDD MP L=0.5 W=1.8 AD=1.98 PD=5.8 AS=1.89 PS=5.7
M541 471 170 VDD VDD MP L=0.5 W=1.8 AD=1.98 PD=5.8 AS=1.89 PS=5.7
M542 472 171 VDD VDD MP L=0.5 W=1.8 AD=1.98 PD=5.8 AS=1.89 PS=5.7
M543 473 172 VDD VDD MP L=0.5 W=1.8 AD=1.98 PD=5.8 AS=1.89 PS=5.7
M544 474 173 VDD VDD MP L=0.5 W=1.8 AD=1.98 PD=5.8 AS=1.89 PS=5.7
M545 VDD 475 159 VDD MP L=0.5 W=1.8 AD=1.89 PD=5.7 AS=1.125 PS=3.05
M546 VDD 476 160 VDD MP L=0.5 W=1.8 AD=1.89 PD=5.7 AS=1.125 PS=3.05
M547 VDD 477 161 VDD MP L=0.5 W=1.8 AD=1.89 PD=5.7 AS=1.125 PS=3.05
M548 VDD 478 162 VDD MP L=0.5 W=1.8 AD=1.89 PD=5.7 AS=1.125 PS=3.05
M549 VDD 479 163 VDD MP L=0.5 W=1.8 AD=1.89 PD=5.7 AS=1.125 PS=3.05
M550 VDD 480 164 VDD MP L=0.5 W=1.8 AD=1.89 PD=5.7 AS=1.125 PS=3.05
M551 VDD 481 165 VDD MP L=0.5 W=1.8 AD=1.89 PD=5.7 AS=1.125 PS=3.05
M552 475 28 VDD VDD MP L=0.5 W=1.8 AD=1.125 PD=3.05 AS=2.25 PS=6.1
M553 476 29 VDD VDD MP L=0.5 W=1.8 AD=1.125 PD=3.05 AS=2.25 PS=6.1
M554 477 30 VDD VDD MP L=0.5 W=1.8 AD=1.125 PD=3.05 AS=2.25 PS=6.1
M555 478 31 VDD VDD MP L=0.5 W=1.8 AD=1.125 PD=3.05 AS=2.25 PS=6.1
M556 479 32 VDD VDD MP L=0.5 W=1.8 AD=1.125 PD=3.05 AS=2.25 PS=6.1
M557 480 33 VDD VDD MP L=0.5 W=1.8 AD=1.125 PD=3.05 AS=2.25 PS=6.1
M558 481 34 VDD VDD MP L=0.5 W=1.8 AD=1.125 PD=3.05 AS=2.25 PS=6.1
M559 150 166 159 VDD MP L=0.5 W=1.8 AD=1.98 PD=5.8 AS=1.125 PS=3.05
M560 151 167 160 VDD MP L=0.5 W=1.8 AD=1.98 PD=5.8 AS=1.125 PS=3.05
M561 152 168 161 VDD MP L=0.5 W=1.8 AD=1.98 PD=5.8 AS=1.125 PS=3.05
M562 153 169 162 VDD MP L=0.5 W=1.8 AD=1.98 PD=5.8 AS=1.125 PS=3.05
M563 154 170 163 VDD MP L=0.5 W=1.8 AD=1.98 PD=5.8 AS=1.125 PS=3.05
M564 155 171 164 VDD MP L=0.5 W=1.8 AD=1.98 PD=5.8 AS=1.125 PS=3.05
M565 156 172 165 VDD MP L=0.5 W=1.8 AD=1.98 PD=5.8 AS=1.125 PS=3.05
M566 130 173 158 VDD MP L=0.5 W=1.8 AD=1.98 PD=5.8 AS=1.125 PS=3.05
M567 174 482 VDD VDD MP L=0.5 W=1.8 AD=1.98 PD=5.8 AS=1.125 PS=3.05
M568 GND 467 150 VDD MP L=0.5 W=1.8 AD=1.125 PD=3.05 AS=1.89 PS=5.7
M569 150 468 151 VDD MP L=0.5 W=1.8 AD=1.125 PD=3.05 AS=1.89 PS=5.7
M570 151 469 152 VDD MP L=0.5 W=1.8 AD=1.125 PD=3.05 AS=1.89 PS=5.7
M571 152 470 153 VDD MP L=0.5 W=1.8 AD=1.125 PD=3.05 AS=1.89 PS=5.7
M572 153 471 154 VDD MP L=0.5 W=1.8 AD=1.125 PD=3.05 AS=1.89 PS=5.7
M573 154 472 155 VDD MP L=0.5 W=1.8 AD=1.125 PD=3.05 AS=1.89 PS=5.7
M574 155 473 156 VDD MP L=0.5 W=1.8 AD=1.125 PD=3.05 AS=1.89 PS=5.7
M575 156 474 130 VDD MP L=0.5 W=1.8 AD=1.125 PD=3.05 AS=1.89 PS=5.7
M576 VDD 174 475 VDD MP L=0.5 W=1.8 AD=1.125 PD=3.05 AS=1.98 PS=5.8
M577 VDD 174 476 VDD MP L=0.5 W=1.8 AD=1.125 PD=3.05 AS=1.98 PS=5.8
M578 VDD 174 477 VDD MP L=0.5 W=1.8 AD=1.125 PD=3.05 AS=1.98 PS=5.8
M579 VDD 174 478 VDD MP L=0.5 W=1.8 AD=1.125 PD=3.05 AS=1.98 PS=5.8
M580 VDD 174 479 VDD MP L=0.5 W=1.8 AD=1.125 PD=3.05 AS=1.98 PS=5.8
M581 VDD 174 480 VDD MP L=0.5 W=1.8 AD=1.125 PD=3.05 AS=1.98 PS=5.8
M582 VDD 174 481 VDD MP L=0.5 W=1.8 AD=1.125 PD=3.05 AS=1.98 PS=5.8
M583 VDD 482 174 VDD MP L=0.5 W=1.8 AD=1.125 PD=3.05 AS=2.25 PS=6.1
M584 482 A<3> VDD VDD MP L=0.5 W=1.8 AD=1.125 PD=3.05 AS=1.98 PS=5.8
M585 877 149 VDD VDD MP L=0.5 W=1.8 AD=2.7 PD=7.5 AS=0.495 PS=2.35
M586 878 142 VDD VDD MP L=0.5 W=1.8 AD=2.7 PD=7.5 AS=0.495 PS=2.35
M587 879 143 VDD VDD MP L=0.5 W=1.8 AD=2.7 PD=7.5 AS=0.495 PS=2.35
M588 880 144 VDD VDD MP L=0.5 W=1.8 AD=2.7 PD=7.5 AS=0.495 PS=2.35
M589 881 145 VDD VDD MP L=0.5 W=1.8 AD=2.7 PD=7.5 AS=0.495 PS=2.35
M590 882 146 VDD VDD MP L=0.5 W=1.8 AD=2.7 PD=7.5 AS=0.495 PS=2.35
M591 883 147 VDD VDD MP L=0.5 W=1.8 AD=2.7 PD=7.5 AS=0.495 PS=2.35
M592 884 148 VDD VDD MP L=0.5 W=1.8 AD=2.7 PD=7.5 AS=0.495 PS=2.35
M593 483 491 176 VDD MP L=0.5 W=1.8 AD=1.89 PD=5.7 AS=1.125 PS=3.05
M594 484 492 177 VDD MP L=0.5 W=1.8 AD=1.89 PD=5.7 AS=1.125 PS=3.05
M595 485 493 178 VDD MP L=0.5 W=1.8 AD=1.89 PD=5.7 AS=1.125 PS=3.05
M596 486 494 179 VDD MP L=0.5 W=1.8 AD=1.89 PD=5.7 AS=1.125 PS=3.05
M597 487 495 180 VDD MP L=0.5 W=1.8 AD=1.89 PD=5.7 AS=1.125 PS=3.05
M598 488 496 181 VDD MP L=0.5 W=1.8 AD=1.89 PD=5.7 AS=1.125 PS=3.05
M599 489 497 182 VDD MP L=0.5 W=1.8 AD=1.89 PD=5.7 AS=1.125 PS=3.05
M600 490 498 P<10> VDD MP L=0.5 W=1.8 AD=1.89 PD=5.7 AS=1.125 PS=3.05
M601 499 192 877 VDD MP L=0.5 W=1.8 AD=0.495 PD=2.35 AS=1.89 PS=5.7
M602 500 193 878 VDD MP L=0.5 W=1.8 AD=0.495 PD=2.35 AS=1.89 PS=5.7
M603 501 194 879 VDD MP L=0.5 W=1.8 AD=0.495 PD=2.35 AS=1.89 PS=5.7
M604 502 195 880 VDD MP L=0.5 W=1.8 AD=0.495 PD=2.35 AS=1.89 PS=5.7
M605 503 196 881 VDD MP L=0.5 W=1.8 AD=0.495 PD=2.35 AS=1.89 PS=5.7
M606 504 197 882 VDD MP L=0.5 W=1.8 AD=0.495 PD=2.35 AS=1.89 PS=5.7
M607 505 198 883 VDD MP L=0.5 W=1.8 AD=0.495 PD=2.35 AS=1.89 PS=5.7
M608 506 199 884 VDD MP L=0.5 W=1.8 AD=0.495 PD=2.35 AS=1.89 PS=5.7
M609 VDD 200 483 VDD MP L=0.5 W=1.8 AD=1.125 PD=3.05 AS=3.06 PS=7.9
M610 VDD 201 484 VDD MP L=0.5 W=1.8 AD=1.125 PD=3.05 AS=3.06 PS=7.9
M611 VDD 202 485 VDD MP L=0.5 W=1.8 AD=1.125 PD=3.05 AS=3.06 PS=7.9
M612 VDD 203 486 VDD MP L=0.5 W=1.8 AD=1.125 PD=3.05 AS=3.06 PS=7.9
M613 VDD 204 487 VDD MP L=0.5 W=1.8 AD=1.125 PD=3.05 AS=3.06 PS=7.9
M614 VDD 205 488 VDD MP L=0.5 W=1.8 AD=1.125 PD=3.05 AS=3.06 PS=7.9
M615 VDD 206 489 VDD MP L=0.5 W=1.8 AD=1.125 PD=3.05 AS=3.06 PS=7.9
M616 VDD 207 490 VDD MP L=0.5 W=1.8 AD=1.125 PD=3.05 AS=3.06 PS=7.9
M617 483 GND VDD VDD MP L=0.5 W=1.8 AD=1.53 PD=3.95 AS=1.89 PS=5.7
M618 484 185 VDD VDD MP L=0.5 W=1.8 AD=1.53 PD=3.95 AS=1.89 PS=5.7
M619 485 186 VDD VDD MP L=0.5 W=1.8 AD=1.53 PD=3.95 AS=1.89 PS=5.7
M620 486 187 VDD VDD MP L=0.5 W=1.8 AD=1.53 PD=3.95 AS=1.89 PS=5.7
M621 487 188 VDD VDD MP L=0.5 W=1.8 AD=1.53 PD=3.95 AS=1.89 PS=5.7
M622 488 189 VDD VDD MP L=0.5 W=1.8 AD=1.53 PD=3.95 AS=1.89 PS=5.7
M623 489 190 VDD VDD MP L=0.5 W=1.8 AD=1.53 PD=3.95 AS=1.89 PS=5.7
M624 490 191 VDD VDD MP L=0.5 W=1.8 AD=1.53 PD=3.95 AS=1.89 PS=5.7
M625 VDD 192 507 VDD MP L=0.5 W=1.8 AD=1.89 PD=5.7 AS=1.53 PS=3.95
M626 VDD 193 508 VDD MP L=0.5 W=1.8 AD=1.89 PD=5.7 AS=1.53 PS=3.95
M627 VDD 194 509 VDD MP L=0.5 W=1.8 AD=1.89 PD=5.7 AS=1.53 PS=5.75
M628 VDD 195 510 VDD MP L=0.5 W=1.8 AD=1.89 PD=5.7 AS=1.53 PS=3.95
M629 VDD 196 511 VDD MP L=0.5 W=1.8 AD=1.89 PD=5.7 AS=1.53 PS=3.95
M630 VDD 197 512 VDD MP L=0.5 W=1.8 AD=1.89 PD=5.7 AS=1.53 PS=3.95
M631 VDD 198 513 VDD MP L=0.5 W=1.8 AD=1.89 PD=5.7 AS=1.53 PS=3.95
M632 VDD 199 514 VDD MP L=0.5 W=1.8 AD=1.89 PD=5.7 AS=1.53 PS=5.75
M633 VDD 515 183 VDD MP L=0.5 W=1.8 AD=1.89 PD=5.7 AS=1.125 PS=3.05
M634 885 GND 491 VDD MP L=0.5 W=1.8 AD=1.89 PD=5.7 AS=0.495 PS=2.35
M635 886 185 492 VDD MP L=0.5 W=1.8 AD=1.89 PD=5.7 AS=0.495 PS=2.35
M636 887 186 493 VDD MP L=0.5 W=1.8 AD=1.89 PD=5.7 AS=0.495 PS=2.35
M637 888 187 494 VDD MP L=0.5 W=1.8 AD=1.89 PD=5.7 AS=0.495 PS=2.35
M638 889 188 495 VDD MP L=0.5 W=1.8 AD=1.89 PD=5.7 AS=0.495 PS=2.35
M639 890 189 496 VDD MP L=0.5 W=1.8 AD=1.89 PD=5.7 AS=0.495 PS=2.35
M640 891 190 497 VDD MP L=0.5 W=1.8 AD=1.89 PD=5.7 AS=0.495 PS=2.35
M641 892 191 498 VDD MP L=0.5 W=1.8 AD=1.89 PD=5.7 AS=0.495 PS=2.35
M642 507 149 VDD VDD MP L=0.5 W=1.8 AD=1.53 PD=3.95 AS=2.25 PS=6.1
M643 508 142 VDD VDD MP L=0.5 W=1.8 AD=1.53 PD=3.95 AS=2.25 PS=6.1
M644 509 143 VDD VDD MP L=0.5 W=1.8 AD=1.53 PD=5.75 AS=2.25 PS=6.1
M645 510 144 VDD VDD MP L=0.5 W=1.8 AD=1.53 PD=3.95 AS=2.25 PS=6.1
M646 511 145 VDD VDD MP L=0.5 W=1.8 AD=1.53 PD=3.95 AS=2.25 PS=6.1
M647 512 146 VDD VDD MP L=0.5 W=1.8 AD=1.53 PD=3.95 AS=2.25 PS=6.1
M648 513 147 VDD VDD MP L=0.5 W=1.8 AD=1.53 PD=3.95 AS=2.25 PS=6.1
M649 514 148 VDD VDD MP L=0.5 W=1.8 AD=1.53 PD=5.75 AS=2.25 PS=6.1
M650 515 27 VDD VDD MP L=0.5 W=1.8 AD=1.125 PD=3.05 AS=2.25 PS=6.1
M651 VDD 200 885 VDD MP L=0.5 W=1.8 AD=0.495 PD=2.35 AS=2.7 PS=7.5
M652 VDD 201 886 VDD MP L=0.5 W=1.8 AD=0.495 PD=2.35 AS=2.7 PS=7.5
M653 VDD 202 887 VDD MP L=0.5 W=1.8 AD=0.495 PD=2.35 AS=2.7 PS=7.5
M654 VDD 203 888 VDD MP L=0.5 W=1.8 AD=0.495 PD=2.35 AS=2.7 PS=7.5
M655 VDD 204 889 VDD MP L=0.5 W=1.8 AD=0.495 PD=2.35 AS=2.7 PS=7.5
M656 VDD 205 890 VDD MP L=0.5 W=1.8 AD=0.495 PD=2.35 AS=2.7 PS=7.5
M657 VDD 206 891 VDD MP L=0.5 W=1.8 AD=0.495 PD=2.35 AS=2.7 PS=7.5
M658 VDD 207 892 VDD MP L=0.5 W=1.8 AD=0.495 PD=2.35 AS=2.7 PS=7.5
M659 200 499 507 VDD MP L=0.5 W=1.8 AD=1.125 PD=3.05 AS=1.89 PS=5.7
M660 201 500 508 VDD MP L=0.5 W=1.8 AD=1.125 PD=3.05 AS=1.89 PS=5.7
M661 202 501 509 VDD MP L=0.5 W=1.8 AD=1.125 PD=3.05 AS=1.89 PS=5.7
M662 203 502 510 VDD MP L=0.5 W=1.8 AD=1.125 PD=3.05 AS=1.89 PS=5.7
M663 204 503 511 VDD MP L=0.5 W=1.8 AD=1.125 PD=3.05 AS=1.89 PS=5.7
M664 205 504 512 VDD MP L=0.5 W=1.8 AD=1.125 PD=3.05 AS=1.89 PS=5.7
M665 206 505 513 VDD MP L=0.5 W=1.8 AD=1.125 PD=3.05 AS=1.89 PS=5.7
M666 207 506 514 VDD MP L=0.5 W=1.8 AD=1.125 PD=3.05 AS=1.89 PS=5.7
M667 VDD 208 515 VDD MP L=0.5 W=1.8 AD=1.125 PD=3.05 AS=1.98 PS=5.8
M668 516 200 VDD VDD MP L=0.5 W=1.8 AD=1.98 PD=5.8 AS=1.89 PS=5.7
M669 517 201 VDD VDD MP L=0.5 W=1.8 AD=1.98 PD=5.8 AS=1.89 PS=5.7
M670 518 202 VDD VDD MP L=0.5 W=1.8 AD=1.98 PD=5.8 AS=1.89 PS=5.7
M671 519 203 VDD VDD MP L=0.5 W=1.8 AD=1.98 PD=5.8 AS=1.89 PS=5.7
M672 520 204 VDD VDD MP L=0.5 W=1.8 AD=1.98 PD=5.8 AS=1.89 PS=5.7
M673 521 205 VDD VDD MP L=0.5 W=1.8 AD=1.98 PD=5.8 AS=1.89 PS=5.7
M674 522 206 VDD VDD MP L=0.5 W=1.8 AD=1.98 PD=5.8 AS=1.89 PS=5.7
M675 523 207 VDD VDD MP L=0.5 W=1.8 AD=1.98 PD=5.8 AS=1.89 PS=5.7
M676 VDD 524 192 VDD MP L=0.5 W=1.8 AD=1.89 PD=5.7 AS=1.125 PS=3.05
M677 VDD 525 193 VDD MP L=0.5 W=1.8 AD=1.89 PD=5.7 AS=1.125 PS=3.05
M678 VDD 526 194 VDD MP L=0.5 W=1.8 AD=1.89 PD=5.7 AS=1.125 PS=3.05
M679 VDD 527 195 VDD MP L=0.5 W=1.8 AD=1.89 PD=5.7 AS=1.125 PS=3.05
M680 VDD 528 196 VDD MP L=0.5 W=1.8 AD=1.89 PD=5.7 AS=1.125 PS=3.05
M681 VDD 529 197 VDD MP L=0.5 W=1.8 AD=1.89 PD=5.7 AS=1.125 PS=3.05
M682 VDD 530 198 VDD MP L=0.5 W=1.8 AD=1.89 PD=5.7 AS=1.125 PS=3.05
M683 208 531 VDD VDD MP L=0.5 W=1.8 AD=1.98 PD=5.8 AS=1.125 PS=3.05
M684 524 28 VDD VDD MP L=0.5 W=1.8 AD=1.125 PD=3.05 AS=2.25 PS=6.1
M685 525 29 VDD VDD MP L=0.5 W=1.8 AD=1.125 PD=3.05 AS=2.25 PS=6.1
M686 526 30 VDD VDD MP L=0.5 W=1.8 AD=1.125 PD=3.05 AS=2.25 PS=6.1
M687 527 31 VDD VDD MP L=0.5 W=1.8 AD=1.125 PD=3.05 AS=2.25 PS=6.1
M688 528 32 VDD VDD MP L=0.5 W=1.8 AD=1.125 PD=3.05 AS=2.25 PS=6.1
M689 529 33 VDD VDD MP L=0.5 W=1.8 AD=1.125 PD=3.05 AS=2.25 PS=6.1
M690 530 34 VDD VDD MP L=0.5 W=1.8 AD=1.125 PD=3.05 AS=2.25 PS=6.1
M691 185 200 192 VDD MP L=0.5 W=1.8 AD=1.98 PD=5.8 AS=1.125 PS=3.05
M692 186 201 193 VDD MP L=0.5 W=1.8 AD=1.98 PD=5.8 AS=1.125 PS=3.05
M693 187 202 194 VDD MP L=0.5 W=1.8 AD=1.98 PD=5.8 AS=1.125 PS=3.05
M694 188 203 195 VDD MP L=0.5 W=1.8 AD=1.98 PD=5.8 AS=1.125 PS=3.05
M695 189 204 196 VDD MP L=0.5 W=1.8 AD=1.98 PD=5.8 AS=1.125 PS=3.05
M696 190 205 197 VDD MP L=0.5 W=1.8 AD=1.98 PD=5.8 AS=1.125 PS=3.05
M697 191 206 198 VDD MP L=0.5 W=1.8 AD=1.98 PD=5.8 AS=1.125 PS=3.05
M698 158 207 199 VDD MP L=0.5 W=1.8 AD=1.98 PD=5.8 AS=1.125 PS=3.05
M699 VDD 531 208 VDD MP L=0.5 W=1.8 AD=1.125 PD=3.05 AS=2.25 PS=6.1
M700 GND 516 185 VDD MP L=0.5 W=1.8 AD=1.125 PD=3.05 AS=1.89 PS=5.7
M701 185 517 186 VDD MP L=0.5 W=1.8 AD=1.125 PD=3.05 AS=1.89 PS=5.7
M702 186 518 187 VDD MP L=0.5 W=1.8 AD=1.125 PD=3.05 AS=1.89 PS=5.7
M703 187 519 188 VDD MP L=0.5 W=1.8 AD=1.125 PD=3.05 AS=1.89 PS=5.7
M704 188 520 189 VDD MP L=0.5 W=1.8 AD=1.125 PD=3.05 AS=1.89 PS=5.7
M705 189 521 190 VDD MP L=0.5 W=1.8 AD=1.125 PD=3.05 AS=1.89 PS=5.7
M706 190 522 191 VDD MP L=0.5 W=1.8 AD=1.125 PD=3.05 AS=1.89 PS=5.7
M707 191 523 158 VDD MP L=0.5 W=1.8 AD=1.125 PD=3.05 AS=1.89 PS=5.7
M708 VDD 208 524 VDD MP L=0.5 W=1.8 AD=1.125 PD=3.05 AS=1.98 PS=5.8
M709 VDD 208 525 VDD MP L=0.5 W=1.8 AD=1.125 PD=3.05 AS=1.98 PS=5.8
M710 VDD 208 526 VDD MP L=0.5 W=1.8 AD=1.125 PD=3.05 AS=1.98 PS=5.8
M711 VDD 208 527 VDD MP L=0.5 W=1.8 AD=1.125 PD=3.05 AS=1.98 PS=5.8
M712 VDD 208 528 VDD MP L=0.5 W=1.8 AD=1.125 PD=3.05 AS=1.98 PS=5.8
M713 VDD 208 529 VDD MP L=0.5 W=1.8 AD=1.125 PD=3.05 AS=1.98 PS=5.8
M714 VDD 208 530 VDD MP L=0.5 W=1.8 AD=1.125 PD=3.05 AS=1.98 PS=5.8
M715 531 A<2> VDD VDD MP L=0.5 W=1.8 AD=1.125 PD=3.05 AS=1.98 PS=5.8
M716 893 183 VDD VDD MP L=0.5 W=1.8 AD=2.7 PD=7.5 AS=0.495 PS=2.35
M717 894 176 VDD VDD MP L=0.5 W=1.8 AD=2.7 PD=7.5 AS=0.495 PS=2.35
M718 895 177 VDD VDD MP L=0.5 W=1.8 AD=2.7 PD=7.5 AS=0.495 PS=2.35
M719 896 178 VDD VDD MP L=0.5 W=1.8 AD=2.7 PD=7.5 AS=0.495 PS=2.35
M720 897 179 VDD VDD MP L=0.5 W=1.8 AD=2.7 PD=7.5 AS=0.495 PS=2.35
M721 898 180 VDD VDD MP L=0.5 W=1.8 AD=2.7 PD=7.5 AS=0.495 PS=2.35
M722 899 181 VDD VDD MP L=0.5 W=1.8 AD=2.7 PD=7.5 AS=0.495 PS=2.35
M723 900 182 VDD VDD MP L=0.5 W=1.8 AD=2.7 PD=7.5 AS=0.495 PS=2.35
M724 532 540 210 VDD MP L=0.5 W=1.8 AD=1.89 PD=5.7 AS=1.125 PS=3.05
M725 533 541 211 VDD MP L=0.5 W=1.8 AD=1.89 PD=5.7 AS=1.125 PS=3.05
M726 534 542 212 VDD MP L=0.5 W=1.8 AD=1.89 PD=5.7 AS=1.125 PS=3.05
M727 535 543 213 VDD MP L=0.5 W=1.8 AD=1.89 PD=5.7 AS=1.125 PS=3.05
M728 536 544 214 VDD MP L=0.5 W=1.8 AD=1.89 PD=5.7 AS=1.125 PS=3.05
M729 537 545 215 VDD MP L=0.5 W=1.8 AD=1.89 PD=5.7 AS=1.125 PS=3.05
M730 538 546 216 VDD MP L=0.5 W=1.8 AD=1.89 PD=5.7 AS=1.125 PS=3.05
M731 539 547 P<9> VDD MP L=0.5 W=1.8 AD=1.89 PD=5.7 AS=1.125 PS=3.05
M732 548 227 893 VDD MP L=0.5 W=1.8 AD=0.495 PD=2.35 AS=1.89 PS=5.7
M733 549 228 894 VDD MP L=0.5 W=1.8 AD=0.495 PD=2.35 AS=1.89 PS=5.7
M734 550 229 895 VDD MP L=0.5 W=1.8 AD=0.495 PD=2.35 AS=1.89 PS=5.7
M735 551 230 896 VDD MP L=0.5 W=1.8 AD=0.495 PD=2.35 AS=1.89 PS=5.7
M736 552 231 897 VDD MP L=0.5 W=1.8 AD=0.495 PD=2.35 AS=1.89 PS=5.7
M737 553 232 898 VDD MP L=0.5 W=1.8 AD=0.495 PD=2.35 AS=1.89 PS=5.7
M738 554 233 899 VDD MP L=0.5 W=1.8 AD=0.495 PD=2.35 AS=1.89 PS=5.7
M739 555 226 900 VDD MP L=0.5 W=1.8 AD=0.495 PD=2.35 AS=1.89 PS=5.7
M740 VDD 234 532 VDD MP L=0.5 W=1.8 AD=1.125 PD=3.05 AS=3.06 PS=7.9
M741 VDD 235 533 VDD MP L=0.5 W=1.8 AD=1.125 PD=3.05 AS=3.06 PS=7.9
M742 VDD 236 534 VDD MP L=0.5 W=1.8 AD=1.125 PD=3.05 AS=3.06 PS=7.9
M743 VDD 237 535 VDD MP L=0.5 W=1.8 AD=1.125 PD=3.05 AS=3.06 PS=7.9
M744 VDD 238 536 VDD MP L=0.5 W=1.8 AD=1.125 PD=3.05 AS=3.06 PS=7.9
M745 VDD 239 537 VDD MP L=0.5 W=1.8 AD=1.125 PD=3.05 AS=3.06 PS=7.9
M746 VDD 240 538 VDD MP L=0.5 W=1.8 AD=1.125 PD=3.05 AS=3.06 PS=7.9
M747 VDD 241 539 VDD MP L=0.5 W=1.8 AD=1.125 PD=3.05 AS=3.06 PS=7.9
M748 VDD 564 218 VDD MP L=0.5 W=1.8 AD=1.89 PD=5.7 AS=1.125 PS=3.05
M749 532 GND VDD VDD MP L=0.5 W=1.8 AD=1.53 PD=3.95 AS=1.89 PS=5.7
M750 533 219 VDD VDD MP L=0.5 W=1.8 AD=1.53 PD=3.95 AS=1.89 PS=5.7
M751 534 220 VDD VDD MP L=0.5 W=1.8 AD=1.53 PD=3.95 AS=1.89 PS=5.7
M752 535 221 VDD VDD MP L=0.5 W=1.8 AD=1.53 PD=3.95 AS=1.89 PS=5.7
M753 536 222 VDD VDD MP L=0.5 W=1.8 AD=1.53 PD=3.95 AS=1.89 PS=5.7
M754 537 223 VDD VDD MP L=0.5 W=1.8 AD=1.53 PD=3.95 AS=1.89 PS=5.7
M755 538 224 VDD VDD MP L=0.5 W=1.8 AD=1.53 PD=3.95 AS=1.89 PS=5.7
M756 539 225 VDD VDD MP L=0.5 W=1.8 AD=1.53 PD=3.95 AS=1.89 PS=5.7
M757 VDD 227 556 VDD MP L=0.5 W=1.8 AD=1.89 PD=5.7 AS=1.53 PS=3.95
M758 VDD 228 557 VDD MP L=0.5 W=1.8 AD=1.89 PD=5.7 AS=1.53 PS=3.95
M759 VDD 229 558 VDD MP L=0.5 W=1.8 AD=1.89 PD=5.7 AS=1.53 PS=5.75
M760 VDD 230 559 VDD MP L=0.5 W=1.8 AD=1.89 PD=5.7 AS=1.53 PS=3.95
M761 VDD 231 560 VDD MP L=0.5 W=1.8 AD=1.89 PD=5.7 AS=1.53 PS=3.95
M762 VDD 232 561 VDD MP L=0.5 W=1.8 AD=1.89 PD=5.7 AS=1.53 PS=3.95
M763 VDD 233 562 VDD MP L=0.5 W=1.8 AD=1.89 PD=5.7 AS=1.53 PS=3.95
M764 VDD 226 563 VDD MP L=0.5 W=1.8 AD=1.89 PD=5.7 AS=1.53 PS=5.75
M765 564 27 VDD VDD MP L=0.5 W=1.8 AD=1.125 PD=3.05 AS=2.25 PS=6.1
M766 VDD 242 564 VDD MP L=0.5 W=1.8 AD=1.125 PD=3.05 AS=1.98 PS=5.8
M767 901 GND 540 VDD MP L=0.5 W=1.8 AD=1.89 PD=5.7 AS=0.495 PS=2.35
M768 902 219 541 VDD MP L=0.5 W=1.8 AD=1.89 PD=5.7 AS=0.495 PS=2.35
M769 903 220 542 VDD MP L=0.5 W=1.8 AD=1.89 PD=5.7 AS=0.495 PS=2.35
M770 904 221 543 VDD MP L=0.5 W=1.8 AD=1.89 PD=5.7 AS=0.495 PS=2.35
M771 905 222 544 VDD MP L=0.5 W=1.8 AD=1.89 PD=5.7 AS=0.495 PS=2.35
M772 906 223 545 VDD MP L=0.5 W=1.8 AD=1.89 PD=5.7 AS=0.495 PS=2.35
M773 907 224 546 VDD MP L=0.5 W=1.8 AD=1.89 PD=5.7 AS=0.495 PS=2.35
M774 908 225 547 VDD MP L=0.5 W=1.8 AD=1.89 PD=5.7 AS=0.495 PS=2.35
M775 556 183 VDD VDD MP L=0.5 W=1.8 AD=1.53 PD=3.95 AS=2.25 PS=6.1
M776 557 176 VDD VDD MP L=0.5 W=1.8 AD=1.53 PD=3.95 AS=2.25 PS=6.1
M777 558 177 VDD VDD MP L=0.5 W=1.8 AD=1.53 PD=5.75 AS=2.25 PS=6.1
M778 559 178 VDD VDD MP L=0.5 W=1.8 AD=1.53 PD=3.95 AS=2.25 PS=6.1
M779 560 179 VDD VDD MP L=0.5 W=1.8 AD=1.53 PD=3.95 AS=2.25 PS=6.1
M780 561 180 VDD VDD MP L=0.5 W=1.8 AD=1.53 PD=3.95 AS=2.25 PS=6.1
M781 562 181 VDD VDD MP L=0.5 W=1.8 AD=1.53 PD=3.95 AS=2.25 PS=6.1
M782 563 182 VDD VDD MP L=0.5 W=1.8 AD=1.53 PD=5.75 AS=2.25 PS=6.1
M783 VDD 234 901 VDD MP L=0.5 W=1.8 AD=0.495 PD=2.35 AS=2.7 PS=7.5
M784 VDD 235 902 VDD MP L=0.5 W=1.8 AD=0.495 PD=2.35 AS=2.7 PS=7.5
M785 VDD 236 903 VDD MP L=0.5 W=1.8 AD=0.495 PD=2.35 AS=2.7 PS=7.5
M786 VDD 237 904 VDD MP L=0.5 W=1.8 AD=0.495 PD=2.35 AS=2.7 PS=7.5
M787 VDD 238 905 VDD MP L=0.5 W=1.8 AD=0.495 PD=2.35 AS=2.7 PS=7.5
M788 VDD 239 906 VDD MP L=0.5 W=1.8 AD=0.495 PD=2.35 AS=2.7 PS=7.5
M789 VDD 240 907 VDD MP L=0.5 W=1.8 AD=0.495 PD=2.35 AS=2.7 PS=7.5
M790 VDD 241 908 VDD MP L=0.5 W=1.8 AD=0.495 PD=2.35 AS=2.7 PS=7.5
M791 234 548 556 VDD MP L=0.5 W=1.8 AD=1.125 PD=3.05 AS=1.89 PS=5.7
M792 235 549 557 VDD MP L=0.5 W=1.8 AD=1.125 PD=3.05 AS=1.89 PS=5.7
M793 236 550 558 VDD MP L=0.5 W=1.8 AD=1.125 PD=3.05 AS=1.89 PS=5.7
M794 237 551 559 VDD MP L=0.5 W=1.8 AD=1.125 PD=3.05 AS=1.89 PS=5.7
M795 238 552 560 VDD MP L=0.5 W=1.8 AD=1.125 PD=3.05 AS=1.89 PS=5.7
M796 239 553 561 VDD MP L=0.5 W=1.8 AD=1.125 PD=3.05 AS=1.89 PS=5.7
M797 240 554 562 VDD MP L=0.5 W=1.8 AD=1.125 PD=3.05 AS=1.89 PS=5.7
M798 241 555 563 VDD MP L=0.5 W=1.8 AD=1.125 PD=3.05 AS=1.89 PS=5.7
M799 565 234 VDD VDD MP L=0.5 W=1.8 AD=1.98 PD=5.8 AS=1.89 PS=5.7
M800 566 235 VDD VDD MP L=0.5 W=1.8 AD=1.98 PD=5.8 AS=1.89 PS=5.7
M801 567 236 VDD VDD MP L=0.5 W=1.8 AD=1.98 PD=5.8 AS=1.89 PS=5.7
M802 568 237 VDD VDD MP L=0.5 W=1.8 AD=1.98 PD=5.8 AS=1.89 PS=5.7
M803 569 238 VDD VDD MP L=0.5 W=1.8 AD=1.98 PD=5.8 AS=1.89 PS=5.7
M804 570 239 VDD VDD MP L=0.5 W=1.8 AD=1.98 PD=5.8 AS=1.89 PS=5.7
M805 571 240 VDD VDD MP L=0.5 W=1.8 AD=1.98 PD=5.8 AS=1.89 PS=5.7
M806 572 241 VDD VDD MP L=0.5 W=1.8 AD=1.98 PD=5.8 AS=1.89 PS=5.7
M807 242 580 VDD VDD MP L=0.5 W=1.8 AD=1.98 PD=5.8 AS=1.125 PS=3.05
M808 VDD 573 227 VDD MP L=0.5 W=1.8 AD=1.89 PD=5.7 AS=1.125 PS=3.05
M809 VDD 574 228 VDD MP L=0.5 W=1.8 AD=1.89 PD=5.7 AS=1.125 PS=3.05
M810 VDD 575 229 VDD MP L=0.5 W=1.8 AD=1.89 PD=5.7 AS=1.125 PS=3.05
M811 VDD 576 230 VDD MP L=0.5 W=1.8 AD=1.89 PD=5.7 AS=1.125 PS=3.05
M812 VDD 577 231 VDD MP L=0.5 W=1.8 AD=1.89 PD=5.7 AS=1.125 PS=3.05
M813 VDD 578 232 VDD MP L=0.5 W=1.8 AD=1.89 PD=5.7 AS=1.125 PS=3.05
M814 VDD 579 233 VDD MP L=0.5 W=1.8 AD=1.89 PD=5.7 AS=1.125 PS=3.05
M815 VDD 580 242 VDD MP L=0.5 W=1.8 AD=1.125 PD=3.05 AS=2.25 PS=6.1
M816 573 28 VDD VDD MP L=0.5 W=1.8 AD=1.125 PD=3.05 AS=2.25 PS=6.1
M817 574 29 VDD VDD MP L=0.5 W=1.8 AD=1.125 PD=3.05 AS=2.25 PS=6.1
M818 575 30 VDD VDD MP L=0.5 W=1.8 AD=1.125 PD=3.05 AS=2.25 PS=6.1
M819 576 31 VDD VDD MP L=0.5 W=1.8 AD=1.125 PD=3.05 AS=2.25 PS=6.1
M820 577 32 VDD VDD MP L=0.5 W=1.8 AD=1.125 PD=3.05 AS=2.25 PS=6.1
M821 578 33 VDD VDD MP L=0.5 W=1.8 AD=1.125 PD=3.05 AS=2.25 PS=6.1
M822 579 34 VDD VDD MP L=0.5 W=1.8 AD=1.125 PD=3.05 AS=2.25 PS=6.1
M823 219 234 227 VDD MP L=0.5 W=1.8 AD=1.98 PD=5.8 AS=1.125 PS=3.05
M824 220 235 228 VDD MP L=0.5 W=1.8 AD=1.98 PD=5.8 AS=1.125 PS=3.05
M825 221 236 229 VDD MP L=0.5 W=1.8 AD=1.98 PD=5.8 AS=1.125 PS=3.05
M826 222 237 230 VDD MP L=0.5 W=1.8 AD=1.98 PD=5.8 AS=1.125 PS=3.05
M827 223 238 231 VDD MP L=0.5 W=1.8 AD=1.98 PD=5.8 AS=1.125 PS=3.05
M828 224 239 232 VDD MP L=0.5 W=1.8 AD=1.98 PD=5.8 AS=1.125 PS=3.05
M829 225 240 233 VDD MP L=0.5 W=1.8 AD=1.98 PD=5.8 AS=1.125 PS=3.05
M830 199 241 226 VDD MP L=0.5 W=1.8 AD=1.98 PD=5.8 AS=1.125 PS=3.05
M831 580 A<1> VDD VDD MP L=0.5 W=1.8 AD=1.125 PD=3.05 AS=1.98 PS=5.8
M832 GND 565 219 VDD MP L=0.5 W=1.8 AD=1.125 PD=3.05 AS=1.89 PS=5.7
M833 219 566 220 VDD MP L=0.5 W=1.8 AD=1.125 PD=3.05 AS=1.89 PS=5.7
M834 220 567 221 VDD MP L=0.5 W=1.8 AD=1.125 PD=3.05 AS=1.89 PS=5.7
M835 221 568 222 VDD MP L=0.5 W=1.8 AD=1.125 PD=3.05 AS=1.89 PS=5.7
M836 222 569 223 VDD MP L=0.5 W=1.8 AD=1.125 PD=3.05 AS=1.89 PS=5.7
M837 223 570 224 VDD MP L=0.5 W=1.8 AD=1.125 PD=3.05 AS=1.89 PS=5.7
M838 224 571 225 VDD MP L=0.5 W=1.8 AD=1.125 PD=3.05 AS=1.89 PS=5.7
M839 225 572 199 VDD MP L=0.5 W=1.8 AD=1.125 PD=3.05 AS=1.89 PS=5.7
M840 VDD 242 573 VDD MP L=0.5 W=1.8 AD=1.125 PD=3.05 AS=1.98 PS=5.8
M841 VDD 242 574 VDD MP L=0.5 W=1.8 AD=1.125 PD=3.05 AS=1.98 PS=5.8
M842 VDD 242 575 VDD MP L=0.5 W=1.8 AD=1.125 PD=3.05 AS=1.98 PS=5.8
M843 VDD 242 576 VDD MP L=0.5 W=1.8 AD=1.125 PD=3.05 AS=1.98 PS=5.8
M844 VDD 242 577 VDD MP L=0.5 W=1.8 AD=1.125 PD=3.05 AS=1.98 PS=5.8
M845 VDD 242 578 VDD MP L=0.5 W=1.8 AD=1.125 PD=3.05 AS=1.98 PS=5.8
M846 VDD 242 579 VDD MP L=0.5 W=1.8 AD=1.125 PD=3.05 AS=1.98 PS=5.8
M847 909 218 VDD VDD MP L=0.5 W=1.8 AD=2.7 PD=7.5 AS=0.495 PS=2.35
M848 910 210 VDD VDD MP L=0.5 W=1.8 AD=2.7 PD=7.5 AS=0.495 PS=2.35
M849 911 211 VDD VDD MP L=0.5 W=1.8 AD=2.7 PD=7.5 AS=0.495 PS=2.35
M850 912 212 VDD VDD MP L=0.5 W=1.8 AD=2.7 PD=7.5 AS=0.495 PS=2.35
M851 913 213 VDD VDD MP L=0.5 W=1.8 AD=2.7 PD=7.5 AS=0.495 PS=2.35
M852 914 214 VDD VDD MP L=0.5 W=1.8 AD=2.7 PD=7.5 AS=0.495 PS=2.35
M853 915 215 VDD VDD MP L=0.5 W=1.8 AD=2.7 PD=7.5 AS=0.495 PS=2.35
M854 916 216 VDD VDD MP L=0.5 W=1.8 AD=2.7 PD=7.5 AS=0.495 PS=2.35
M855 581 589 P<1> VDD MP L=0.5 W=1.8 AD=1.89 PD=5.7 AS=1.125 PS=3.05
M856 582 590 P<2> VDD MP L=0.5 W=1.8 AD=1.89 PD=5.7 AS=1.125 PS=3.05
M857 583 591 P<3> VDD MP L=0.5 W=1.8 AD=1.89 PD=5.7 AS=1.125 PS=3.05
M858 584 592 P<4> VDD MP L=0.5 W=1.8 AD=1.89 PD=5.7 AS=1.125 PS=3.05
M859 585 593 P<5> VDD MP L=0.5 W=1.8 AD=1.89 PD=5.7 AS=1.125 PS=3.05
M860 586 594 P<6> VDD MP L=0.5 W=1.8 AD=1.89 PD=5.7 AS=1.125 PS=3.05
M861 587 595 P<7> VDD MP L=0.5 W=1.8 AD=1.89 PD=5.7 AS=1.125 PS=3.05
M862 588 596 P<8> VDD MP L=0.5 W=1.8 AD=1.89 PD=5.7 AS=1.125 PS=3.05
M863 VDD 605 P<0> VDD MP L=0.5 W=1.8 AD=1.89 PD=5.7 AS=1.125 PS=3.05
M864 597 252 909 VDD MP L=0.5 W=1.8 AD=0.495 PD=2.35 AS=1.89 PS=5.7
M865 598 253 910 VDD MP L=0.5 W=1.8 AD=0.495 PD=2.35 AS=1.89 PS=5.7
M866 599 254 911 VDD MP L=0.5 W=1.8 AD=0.495 PD=2.35 AS=1.89 PS=5.7
M867 600 255 912 VDD MP L=0.5 W=1.8 AD=0.495 PD=2.35 AS=1.89 PS=5.7
M868 601 256 913 VDD MP L=0.5 W=1.8 AD=0.495 PD=2.35 AS=1.89 PS=5.7
M869 602 257 914 VDD MP L=0.5 W=1.8 AD=0.495 PD=2.35 AS=1.89 PS=5.7
M870 603 258 915 VDD MP L=0.5 W=1.8 AD=0.495 PD=2.35 AS=1.89 PS=5.7
M871 604 GND 916 VDD MP L=0.5 W=1.8 AD=0.495 PD=2.35 AS=1.89 PS=5.7
M872 VDD 260 581 VDD MP L=0.5 W=1.8 AD=1.125 PD=3.05 AS=3.06 PS=7.9
M873 VDD 261 582 VDD MP L=0.5 W=1.8 AD=1.125 PD=3.05 AS=3.06 PS=7.9
M874 VDD 262 583 VDD MP L=0.5 W=1.8 AD=1.125 PD=3.05 AS=3.06 PS=7.9
M875 VDD 263 584 VDD MP L=0.5 W=1.8 AD=1.125 PD=3.05 AS=3.06 PS=7.9
M876 VDD 264 585 VDD MP L=0.5 W=1.8 AD=1.125 PD=3.05 AS=3.06 PS=7.9
M877 VDD 265 586 VDD MP L=0.5 W=1.8 AD=1.125 PD=3.05 AS=3.06 PS=7.9
M878 VDD 266 587 VDD MP L=0.5 W=1.8 AD=1.125 PD=3.05 AS=3.06 PS=7.9
M879 VDD 267 588 VDD MP L=0.5 W=1.8 AD=1.125 PD=3.05 AS=3.06 PS=7.9
M880 605 27 VDD VDD MP L=0.5 W=1.8 AD=1.125 PD=3.05 AS=2.25 PS=6.1
M881 581 GND VDD VDD MP L=0.5 W=1.8 AD=1.53 PD=3.95 AS=1.89 PS=5.7
M882 582 245 VDD VDD MP L=0.5 W=1.8 AD=1.53 PD=3.95 AS=1.89 PS=5.7
M883 583 246 VDD VDD MP L=0.5 W=1.8 AD=1.53 PD=3.95 AS=1.89 PS=5.7
M884 584 247 VDD VDD MP L=0.5 W=1.8 AD=1.53 PD=3.95 AS=1.89 PS=5.7
M885 585 248 VDD VDD MP L=0.5 W=1.8 AD=1.53 PD=3.95 AS=1.89 PS=5.7
M886 586 249 VDD VDD MP L=0.5 W=1.8 AD=1.53 PD=3.95 AS=1.89 PS=5.7
M887 587 250 VDD VDD MP L=0.5 W=1.8 AD=1.53 PD=3.95 AS=1.89 PS=5.7
M888 588 251 VDD VDD MP L=0.5 W=1.8 AD=1.53 PD=3.95 AS=1.89 PS=5.7
M889 VDD 259 605 VDD MP L=0.5 W=1.8 AD=1.125 PD=3.05 AS=1.98 PS=5.8
M890 VDD 252 606 VDD MP L=0.5 W=1.8 AD=1.89 PD=5.7 AS=1.53 PS=3.95
M891 VDD 253 607 VDD MP L=0.5 W=1.8 AD=1.89 PD=5.7 AS=1.53 PS=3.95
M892 VDD 254 608 VDD MP L=0.5 W=1.8 AD=1.89 PD=5.7 AS=1.53 PS=5.75
M893 VDD 255 609 VDD MP L=0.5 W=1.8 AD=1.89 PD=5.7 AS=1.53 PS=3.95
M894 VDD 256 610 VDD MP L=0.5 W=1.8 AD=1.89 PD=5.7 AS=1.53 PS=3.95
M895 VDD 257 611 VDD MP L=0.5 W=1.8 AD=1.89 PD=5.7 AS=1.53 PS=3.95
M896 VDD 258 612 VDD MP L=0.5 W=1.8 AD=1.89 PD=5.7 AS=1.53 PS=3.95
M897 VDD GND 613 VDD MP L=0.5 W=1.8 AD=1.89 PD=5.7 AS=1.53 PS=5.75
M898 917 GND 589 VDD MP L=0.5 W=1.8 AD=1.89 PD=5.7 AS=0.495 PS=2.35
M899 918 245 590 VDD MP L=0.5 W=1.8 AD=1.89 PD=5.7 AS=0.495 PS=2.35
M900 919 246 591 VDD MP L=0.5 W=1.8 AD=1.89 PD=5.7 AS=0.495 PS=2.35
M901 920 247 592 VDD MP L=0.5 W=1.8 AD=1.89 PD=5.7 AS=0.495 PS=2.35
M902 921 248 593 VDD MP L=0.5 W=1.8 AD=1.89 PD=5.7 AS=0.495 PS=2.35
M903 922 249 594 VDD MP L=0.5 W=1.8 AD=1.89 PD=5.7 AS=0.495 PS=2.35
M904 923 250 595 VDD MP L=0.5 W=1.8 AD=1.89 PD=5.7 AS=0.495 PS=2.35
M905 924 251 596 VDD MP L=0.5 W=1.8 AD=1.89 PD=5.7 AS=0.495 PS=2.35
M906 606 218 VDD VDD MP L=0.5 W=1.8 AD=1.53 PD=3.95 AS=2.25 PS=6.1
M907 607 210 VDD VDD MP L=0.5 W=1.8 AD=1.53 PD=3.95 AS=2.25 PS=6.1
M908 608 211 VDD VDD MP L=0.5 W=1.8 AD=1.53 PD=5.75 AS=2.25 PS=6.1
M909 609 212 VDD VDD MP L=0.5 W=1.8 AD=1.53 PD=3.95 AS=2.25 PS=6.1
M910 610 213 VDD VDD MP L=0.5 W=1.8 AD=1.53 PD=3.95 AS=2.25 PS=6.1
M911 611 214 VDD VDD MP L=0.5 W=1.8 AD=1.53 PD=3.95 AS=2.25 PS=6.1
M912 612 215 VDD VDD MP L=0.5 W=1.8 AD=1.53 PD=3.95 AS=2.25 PS=6.1
M913 613 216 VDD VDD MP L=0.5 W=1.8 AD=1.53 PD=5.75 AS=2.25 PS=6.1
M914 VDD 260 917 VDD MP L=0.5 W=1.8 AD=0.495 PD=2.35 AS=2.7 PS=7.5
M915 VDD 261 918 VDD MP L=0.5 W=1.8 AD=0.495 PD=2.35 AS=2.7 PS=7.5
M916 VDD 262 919 VDD MP L=0.5 W=1.8 AD=0.495 PD=2.35 AS=2.7 PS=7.5
M917 VDD 263 920 VDD MP L=0.5 W=1.8 AD=0.495 PD=2.35 AS=2.7 PS=7.5
M918 VDD 264 921 VDD MP L=0.5 W=1.8 AD=0.495 PD=2.35 AS=2.7 PS=7.5
M919 VDD 265 922 VDD MP L=0.5 W=1.8 AD=0.495 PD=2.35 AS=2.7 PS=7.5
M920 VDD 266 923 VDD MP L=0.5 W=1.8 AD=0.495 PD=2.35 AS=2.7 PS=7.5
M921 VDD 267 924 VDD MP L=0.5 W=1.8 AD=0.495 PD=2.35 AS=2.7 PS=7.5
M922 260 597 606 VDD MP L=0.5 W=1.8 AD=1.125 PD=3.05 AS=1.89 PS=5.7
M923 261 598 607 VDD MP L=0.5 W=1.8 AD=1.125 PD=3.05 AS=1.89 PS=5.7
M924 262 599 608 VDD MP L=0.5 W=1.8 AD=1.125 PD=3.05 AS=1.89 PS=5.7
M925 263 600 609 VDD MP L=0.5 W=1.8 AD=1.125 PD=3.05 AS=1.89 PS=5.7
M926 264 601 610 VDD MP L=0.5 W=1.8 AD=1.125 PD=3.05 AS=1.89 PS=5.7
M927 265 602 611 VDD MP L=0.5 W=1.8 AD=1.125 PD=3.05 AS=1.89 PS=5.7
M928 266 603 612 VDD MP L=0.5 W=1.8 AD=1.125 PD=3.05 AS=1.89 PS=5.7
M929 267 604 613 VDD MP L=0.5 W=1.8 AD=1.125 PD=3.05 AS=1.89 PS=5.7
M930 259 622 VDD VDD MP L=0.5 W=1.8 AD=1.98 PD=5.8 AS=1.125 PS=3.05
M931 614 260 VDD VDD MP L=0.5 W=1.8 AD=1.98 PD=5.8 AS=1.89 PS=5.7
M932 615 261 VDD VDD MP L=0.5 W=1.8 AD=1.98 PD=5.8 AS=1.89 PS=5.7
M933 616 262 VDD VDD MP L=0.5 W=1.8 AD=1.98 PD=5.8 AS=1.89 PS=5.7
M934 617 263 VDD VDD MP L=0.5 W=1.8 AD=1.98 PD=5.8 AS=1.89 PS=5.7
M935 618 264 VDD VDD MP L=0.5 W=1.8 AD=1.98 PD=5.8 AS=1.89 PS=5.7
M936 619 265 VDD VDD MP L=0.5 W=1.8 AD=1.98 PD=5.8 AS=1.89 PS=5.7
M937 620 266 VDD VDD MP L=0.5 W=1.8 AD=1.98 PD=5.8 AS=1.89 PS=5.7
M938 621 267 VDD VDD MP L=0.5 W=1.8 AD=1.98 PD=5.8 AS=1.89 PS=5.7
M939 VDD 622 259 VDD MP L=0.5 W=1.8 AD=1.125 PD=3.05 AS=2.25 PS=6.1
M940 VDD 623 252 VDD MP L=0.5 W=1.8 AD=1.89 PD=5.7 AS=1.125 PS=3.05
M941 VDD 624 253 VDD MP L=0.5 W=1.8 AD=1.89 PD=5.7 AS=1.125 PS=3.05
M942 VDD 625 254 VDD MP L=0.5 W=1.8 AD=1.89 PD=5.7 AS=1.125 PS=3.05
M943 VDD 626 255 VDD MP L=0.5 W=1.8 AD=1.89 PD=5.7 AS=1.125 PS=3.05
M944 VDD 627 256 VDD MP L=0.5 W=1.8 AD=1.89 PD=5.7 AS=1.125 PS=3.05
M945 VDD 628 257 VDD MP L=0.5 W=1.8 AD=1.89 PD=5.7 AS=1.125 PS=3.05
M946 VDD 629 258 VDD MP L=0.5 W=1.8 AD=1.89 PD=5.7 AS=1.125 PS=3.05
M947 622 A<0> VDD VDD MP L=0.5 W=1.8 AD=1.125 PD=3.05 AS=1.98 PS=5.8
M948 623 28 VDD VDD MP L=0.5 W=1.8 AD=1.125 PD=3.05 AS=2.25 PS=6.1
M949 624 29 VDD VDD MP L=0.5 W=1.8 AD=1.125 PD=3.05 AS=2.25 PS=6.1
M950 625 30 VDD VDD MP L=0.5 W=1.8 AD=1.125 PD=3.05 AS=2.25 PS=6.1
M951 626 31 VDD VDD MP L=0.5 W=1.8 AD=1.125 PD=3.05 AS=2.25 PS=6.1
M952 627 32 VDD VDD MP L=0.5 W=1.8 AD=1.125 PD=3.05 AS=2.25 PS=6.1
M953 628 33 VDD VDD MP L=0.5 W=1.8 AD=1.125 PD=3.05 AS=2.25 PS=6.1
M954 629 34 VDD VDD MP L=0.5 W=1.8 AD=1.125 PD=3.05 AS=2.25 PS=6.1
M955 245 260 252 VDD MP L=0.5 W=1.8 AD=1.98 PD=5.8 AS=1.125 PS=3.05
M956 246 261 253 VDD MP L=0.5 W=1.8 AD=1.98 PD=5.8 AS=1.125 PS=3.05
M957 247 262 254 VDD MP L=0.5 W=1.8 AD=1.98 PD=5.8 AS=1.125 PS=3.05
M958 248 263 255 VDD MP L=0.5 W=1.8 AD=1.98 PD=5.8 AS=1.125 PS=3.05
M959 249 264 256 VDD MP L=0.5 W=1.8 AD=1.98 PD=5.8 AS=1.125 PS=3.05
M960 250 265 257 VDD MP L=0.5 W=1.8 AD=1.98 PD=5.8 AS=1.125 PS=3.05
M961 251 266 258 VDD MP L=0.5 W=1.8 AD=1.98 PD=5.8 AS=1.125 PS=3.05
M962 226 267 GND VDD MP L=0.5 W=1.8 AD=1.98 PD=5.8 AS=1.125 PS=3.05
M963 GND 614 245 VDD MP L=0.5 W=1.8 AD=1.125 PD=3.05 AS=1.89 PS=5.7
M964 245 615 246 VDD MP L=0.5 W=1.8 AD=1.125 PD=3.05 AS=1.89 PS=5.7
M965 246 616 247 VDD MP L=0.5 W=1.8 AD=1.125 PD=3.05 AS=1.89 PS=5.7
M966 247 617 248 VDD MP L=0.5 W=1.8 AD=1.125 PD=3.05 AS=1.89 PS=5.7
M967 248 618 249 VDD MP L=0.5 W=1.8 AD=1.125 PD=3.05 AS=1.89 PS=5.7
M968 249 619 250 VDD MP L=0.5 W=1.8 AD=1.125 PD=3.05 AS=1.89 PS=5.7
M969 250 620 251 VDD MP L=0.5 W=1.8 AD=1.125 PD=3.05 AS=1.89 PS=5.7
M970 251 621 226 VDD MP L=0.5 W=1.8 AD=1.125 PD=3.05 AS=1.89 PS=5.7
M971 VDD 259 623 VDD MP L=0.5 W=1.8 AD=1.125 PD=3.05 AS=1.98 PS=5.8
M972 VDD 259 624 VDD MP L=0.5 W=1.8 AD=1.125 PD=3.05 AS=1.98 PS=5.8
M973 VDD 259 625 VDD MP L=0.5 W=1.8 AD=1.125 PD=3.05 AS=1.98 PS=5.8
M974 VDD 259 626 VDD MP L=0.5 W=1.8 AD=1.125 PD=3.05 AS=1.98 PS=5.8
M975 VDD 259 627 VDD MP L=0.5 W=1.8 AD=1.125 PD=3.05 AS=1.98 PS=5.8
M976 VDD 259 628 VDD MP L=0.5 W=1.8 AD=1.125 PD=3.05 AS=1.98 PS=5.8
M977 VDD 259 629 VDD MP L=0.5 W=1.8 AD=1.125 PD=3.05 AS=1.98 PS=5.8
M978 630 35 OVR GND MN L=0.5 W=0.9 AD=0.945 PD=3.9 AS=0.2475 PS=1.45
M979 GND 269 630 GND MN L=0.5 W=0.9 AD=0.2475 PD=1.45 AS=1.935 PS=6.1
M980 269 P<14> GND GND MN L=0.5 W=0.9 AD=0.9675 PD=3.05 AS=1.125 PS=4.3
M981 GND P<15> 269 GND MN L=0.5 W=0.9 AD=0.5625 PD=2.15 AS=1.935 PS=6.1
M982 269 P<13> GND GND MN L=0.5 W=0.9 AD=0.9675 PD=3.05 AS=1.125 PS=4.3
M983 GND P<12> 269 GND MN L=0.5 W=0.9 AD=0.5625 PD=2.15 AS=1.935 PS=6.1
M984 35 P<11> GND GND MN L=0.5 W=0.9 AD=1.935 PD=6.1 AS=0.5625 PS=2.15
M985 GND B<1> 270 GND MN L=0.5 W=0.9 AD=0.945 PD=3.9 AS=0.9675 PS=3.05
M986 GND B<2> 271 GND MN L=0.5 W=0.9 AD=0.945 PD=3.9 AS=0.9675 PS=3.05
M987 GND B<3> 272 GND MN L=0.5 W=0.9 AD=0.945 PD=3.9 AS=0.9675 PS=3.05
M988 GND B<4> 273 GND MN L=0.5 W=0.9 AD=0.945 PD=3.9 AS=0.9675 PS=3.05
M989 GND B<5> 274 GND MN L=0.5 W=0.9 AD=0.945 PD=3.9 AS=0.9675 PS=3.05
M990 GND B<6> 275 GND MN L=0.5 W=0.9 AD=0.945 PD=3.9 AS=0.9675 PS=3.05
M991 GND B<7> 276 GND MN L=0.5 W=0.9 AD=0.945 PD=3.9 AS=0.9675 PS=3.05
M992 GND 278 19 GND MN L=0.5 W=0.9 AD=0.945 PD=3.9 AS=0.9675 PS=3.05
M993 GND 279 20 GND MN L=0.5 W=0.9 AD=0.945 PD=3.9 AS=0.9675 PS=3.05
M994 GND 280 21 GND MN L=0.5 W=0.9 AD=0.945 PD=3.9 AS=0.9675 PS=3.05
M995 GND 281 22 GND MN L=0.5 W=0.9 AD=0.945 PD=3.9 AS=0.9675 PS=3.05
M996 GND 282 23 GND MN L=0.5 W=0.9 AD=0.945 PD=3.9 AS=0.9675 PS=3.05
M997 GND 283 24 GND MN L=0.5 W=0.9 AD=0.945 PD=3.9 AS=0.9675 PS=3.05
M998 GND 284 25 GND MN L=0.5 W=0.9 AD=0.945 PD=3.9 AS=0.9675 PS=3.05
M999 GND 285 26 GND MN L=0.5 W=0.9 AD=0.945 PD=3.9 AS=0.9675 PS=3.05
M1000 GND B<0> 277 GND MN L=0.5 W=0.9 AD=0.99 PD=4 AS=0.9675 PS=3.05
M1001 GND P<10> 35 GND MN L=0.5 W=0.9 AD=0.5625 PD=2.15 AS=1.935 PS=6.1
M1002 631 27 GND GND MN L=0.5 W=0.9 AD=0.9675 PD=3.05 AS=0.495 PS=2.9
M1003 632 28 GND GND MN L=0.5 W=0.9 AD=0.9675 PD=3.05 AS=0.495 PS=2.9
M1004 633 29 GND GND MN L=0.5 W=0.9 AD=0.9675 PD=3.05 AS=0.495 PS=2.9
M1005 634 30 GND GND MN L=0.5 W=0.9 AD=0.9675 PD=3.05 AS=0.495 PS=2.9
M1006 635 31 GND GND MN L=0.5 W=0.9 AD=0.9675 PD=3.05 AS=0.495 PS=2.9
M1007 636 32 GND GND MN L=0.5 W=0.9 AD=0.9675 PD=3.05 AS=0.495 PS=2.9
M1008 637 33 GND GND MN L=0.5 W=0.9 AD=0.9675 PD=3.05 AS=0.495 PS=2.9
M1009 638 34 GND GND MN L=0.5 W=0.9 AD=1.935 PD=6.1 AS=0.2475 PS=1.45
M1010 28 270 GND GND MN L=0.5 W=0.9 AD=0.9675 PD=3.05 AS=1.125 PS=4.3
M1011 29 271 GND GND MN L=0.5 W=0.9 AD=0.9675 PD=3.05 AS=1.125 PS=4.3
M1012 30 272 GND GND MN L=0.5 W=0.9 AD=0.9675 PD=3.05 AS=1.125 PS=4.3
M1013 31 273 GND GND MN L=0.5 W=0.9 AD=0.9675 PD=3.05 AS=1.125 PS=4.3
M1014 32 274 GND GND MN L=0.5 W=0.9 AD=0.9675 PD=3.05 AS=1.125 PS=4.3
M1015 33 275 GND GND MN L=0.5 W=0.9 AD=0.9675 PD=3.05 AS=1.125 PS=4.3
M1016 34 276 GND GND MN L=0.5 W=0.9 AD=0.9675 PD=3.05 AS=1.125 PS=4.3
M1017 27 277 GND GND MN L=0.5 W=0.9 AD=0.9675 PD=3.05 AS=1.125 PS=4.3
M1018 GND 270 28 GND MN L=0.5 W=0.9 AD=0.5625 PD=2.15 AS=1.8 PS=5.8
M1019 GND 271 29 GND MN L=0.5 W=0.9 AD=0.5625 PD=2.15 AS=1.8 PS=5.8
M1020 GND 272 30 GND MN L=0.5 W=0.9 AD=0.5625 PD=2.15 AS=1.8 PS=5.8
M1021 GND 273 31 GND MN L=0.5 W=0.9 AD=0.5625 PD=2.15 AS=1.8 PS=5.8
M1022 GND 274 32 GND MN L=0.5 W=0.9 AD=0.5625 PD=2.15 AS=1.8 PS=5.8
M1023 GND 275 33 GND MN L=0.5 W=0.9 AD=0.5625 PD=2.15 AS=1.8 PS=5.8
M1024 GND 276 34 GND MN L=0.5 W=0.9 AD=0.5625 PD=2.15 AS=1.8 PS=5.8
M1025 278 36 631 GND MN L=0.5 W=0.9 AD=0.2475 PD=1.45 AS=0.99 PS=4
M1026 279 36 632 GND MN L=0.5 W=0.9 AD=0.2475 PD=1.45 AS=0.99 PS=4
M1027 280 36 633 GND MN L=0.5 W=0.9 AD=0.2475 PD=1.45 AS=0.99 PS=4
M1028 281 36 634 GND MN L=0.5 W=0.9 AD=0.2475 PD=1.45 AS=0.99 PS=4
M1029 282 36 635 GND MN L=0.5 W=0.9 AD=0.2475 PD=1.45 AS=0.99 PS=4
M1030 283 36 636 GND MN L=0.5 W=0.9 AD=0.2475 PD=1.45 AS=0.99 PS=4
M1031 284 36 637 GND MN L=0.5 W=0.9 AD=0.2475 PD=1.45 AS=0.99 PS=4
M1032 285 36 638 GND MN L=0.5 W=0.9 AD=0.2475 PD=1.45 AS=0.99 PS=4
M1033 35 P<9> GND GND MN L=0.5 W=0.9 AD=0.9675 PD=3.05 AS=1.125 PS=4.3
M1034 GND 277 27 GND MN L=0.5 W=0.9 AD=0.5625 PD=2.15 AS=1.755 PS=5.7
M1035 GND P<8> 35 GND MN L=0.5 W=0.9 AD=0.5625 PD=2.15 AS=1.755 PS=5.7
M1036 38 294 GND GND MN L=0.5 W=0.9 AD=2.565 PD=7.5 AS=0.5625 PS=2.15
M1037 39 295 GND GND MN L=0.5 W=0.9 AD=2.565 PD=7.5 AS=0.5625 PS=2.15
M1038 40 296 GND GND MN L=0.5 W=0.9 AD=2.565 PD=7.5 AS=0.5625 PS=2.15
M1039 41 297 GND GND MN L=0.5 W=0.9 AD=2.565 PD=7.5 AS=0.5625 PS=2.15
M1040 42 298 GND GND MN L=0.5 W=0.9 AD=2.565 PD=7.5 AS=0.5625 PS=2.15
M1041 43 299 GND GND MN L=0.5 W=0.9 AD=2.565 PD=7.5 AS=0.5625 PS=2.15
M1042 44 300 GND GND MN L=0.5 W=0.9 AD=2.565 PD=7.5 AS=0.5625 PS=2.15
M1043 P<14> 301 GND GND MN L=0.5 W=0.9 AD=2.565 PD=7.5 AS=0.5625 PS=2.15
M1044 639 GND 38 GND MN L=0.5 W=0.9 AD=1.125 PD=4.3 AS=0.2475 PS=1.45
M1045 640 47 39 GND MN L=0.5 W=0.9 AD=0.5625 PD=2.15 AS=0.495 PS=2.9
M1046 641 48 40 GND MN L=0.5 W=0.9 AD=0.5625 PD=2.15 AS=0.495 PS=2.9
M1047 642 49 41 GND MN L=0.5 W=0.9 AD=0.5625 PD=2.15 AS=0.495 PS=2.9
M1048 643 50 42 GND MN L=0.5 W=0.9 AD=0.5625 PD=2.15 AS=0.495 PS=2.9
M1049 644 51 43 GND MN L=0.5 W=0.9 AD=0.5625 PD=2.15 AS=0.495 PS=2.9
M1050 645 52 44 GND MN L=0.5 W=0.9 AD=0.5625 PD=2.15 AS=0.495 PS=2.9
M1051 646 53 P<14> GND MN L=0.5 W=0.9 AD=0.5625 PD=2.15 AS=0.495 PS=2.9
M1052 302 19 GND GND MN L=0.5 W=0.9 AD=2.565 PD=7.5 AS=0.5625 PS=2.15
M1053 303 20 GND GND MN L=0.5 W=0.9 AD=2.565 PD=7.5 AS=0.5625 PS=2.15
M1054 304 21 GND GND MN L=0.5 W=0.9 AD=2.565 PD=7.5 AS=0.5625 PS=2.15
M1055 305 22 GND GND MN L=0.5 W=0.9 AD=2.565 PD=7.5 AS=0.5625 PS=2.15
M1056 306 23 GND GND MN L=0.5 W=0.9 AD=2.565 PD=7.5 AS=0.5625 PS=2.15
M1057 307 24 GND GND MN L=0.5 W=0.9 AD=2.565 PD=7.5 AS=0.5625 PS=2.15
M1058 308 25 GND GND MN L=0.5 W=0.9 AD=2.565 PD=7.5 AS=0.5625 PS=2.15
M1059 309 26 GND GND MN L=0.5 W=0.9 AD=2.565 PD=7.5 AS=0.5625 PS=2.15
M1060 36 318 GND GND MN L=0.5 W=0.9 AD=0.9 PD=2.9 AS=1.125 PS=4.3
M1061 GND 63 639 GND MN L=0.5 W=0.9 AD=0.2475 PD=1.45 AS=1.935 PS=6.1
M1062 GND 64 640 GND MN L=0.5 W=0.9 AD=0.2475 PD=1.45 AS=1.935 PS=6.1
M1063 GND 65 641 GND MN L=0.5 W=0.9 AD=0.2475 PD=1.45 AS=1.935 PS=6.1
M1064 GND 66 642 GND MN L=0.5 W=0.9 AD=0.2475 PD=1.45 AS=1.935 PS=6.1
M1065 GND 67 643 GND MN L=0.5 W=0.9 AD=0.2475 PD=1.45 AS=1.935 PS=6.1
M1066 GND 68 644 GND MN L=0.5 W=0.9 AD=0.2475 PD=1.45 AS=1.935 PS=6.1
M1067 GND 69 645 GND MN L=0.5 W=0.9 AD=0.2475 PD=1.45 AS=1.935 PS=6.1
M1068 GND 70 646 GND MN L=0.5 W=0.9 AD=0.2475 PD=1.45 AS=1.935 PS=6.1
M1069 GND 54 302 GND MN L=0.5 W=0.9 AD=1.125 PD=4.3 AS=0.9675 PS=3.05
M1070 GND 55 303 GND MN L=0.5 W=0.9 AD=0.5625 PD=2.15 AS=1.935 PS=6.1
M1071 GND 56 304 GND MN L=0.5 W=0.9 AD=0.5625 PD=2.15 AS=1.935 PS=6.1
M1072 GND 57 305 GND MN L=0.5 W=0.9 AD=0.5625 PD=2.15 AS=1.935 PS=6.1
M1073 GND 58 306 GND MN L=0.5 W=0.9 AD=0.5625 PD=2.15 AS=1.935 PS=6.1
M1074 GND 59 307 GND MN L=0.5 W=0.9 AD=0.5625 PD=2.15 AS=1.935 PS=6.1
M1075 GND 60 308 GND MN L=0.5 W=0.9 AD=0.5625 PD=2.15 AS=1.935 PS=6.1
M1076 GND 61 309 GND MN L=0.5 W=0.9 AD=0.5625 PD=2.15 AS=1.935 PS=6.1
M1077 GND 318 36 GND MN L=0.5 W=0.9 AD=0.5625 PD=2.15 AS=1.935 PS=6.1
M1078 647 19 GND GND MN L=0.5 W=0.9 AD=0.9675 PD=3.05 AS=0.495 PS=2.9
M1079 648 20 GND GND MN L=0.5 W=0.9 AD=0.9675 PD=3.05 AS=0.495 PS=2.9
M1080 649 21 GND GND MN L=0.5 W=0.9 AD=0.9675 PD=3.05 AS=0.495 PS=2.9
M1081 650 22 GND GND MN L=0.5 W=0.9 AD=0.9675 PD=3.05 AS=0.495 PS=2.9
M1082 651 23 GND GND MN L=0.5 W=0.9 AD=0.9675 PD=3.05 AS=0.495 PS=2.9
M1083 652 24 GND GND MN L=0.5 W=0.9 AD=0.9675 PD=3.05 AS=0.495 PS=2.9
M1084 653 25 GND GND MN L=0.5 W=0.9 AD=0.9675 PD=3.05 AS=0.495 PS=2.9
M1085 654 26 GND GND MN L=0.5 W=0.9 AD=0.9675 PD=3.05 AS=0.495 PS=2.9
M1086 294 GND GND GND MN L=0.5 W=0.9 AD=0.9675 PD=3.05 AS=1.125 PS=4.3
M1087 295 47 GND GND MN L=0.5 W=0.9 AD=0.9675 PD=3.05 AS=1.125 PS=4.3
M1088 296 48 GND GND MN L=0.5 W=0.9 AD=0.9675 PD=3.05 AS=1.125 PS=4.3
M1089 297 49 GND GND MN L=0.5 W=0.9 AD=0.9675 PD=3.05 AS=1.125 PS=4.3
M1090 298 50 GND GND MN L=0.5 W=0.9 AD=0.9675 PD=3.05 AS=1.125 PS=4.3
M1091 299 51 GND GND MN L=0.5 W=0.9 AD=0.9675 PD=3.05 AS=1.125 PS=4.3
M1092 300 52 GND GND MN L=0.5 W=0.9 AD=0.9675 PD=3.05 AS=1.125 PS=4.3
M1093 301 53 GND GND MN L=0.5 W=0.9 AD=0.9675 PD=3.05 AS=1.125 PS=4.3
M1094 318 A<7> GND GND MN L=0.5 W=0.9 AD=1.935 PD=6.1 AS=0.495 PS=2
M1095 GND 63 294 GND MN L=0.5 W=0.9 AD=0.5625 PD=2.15 AS=2.565 PS=7.5
M1096 GND 64 295 GND MN L=0.5 W=0.9 AD=0.5625 PD=2.15 AS=2.565 PS=7.5
M1097 GND 65 296 GND MN L=0.5 W=0.9 AD=0.5625 PD=2.15 AS=2.565 PS=7.5
M1098 GND 66 297 GND MN L=0.5 W=0.9 AD=0.5625 PD=2.15 AS=2.565 PS=7.5
M1099 GND 67 298 GND MN L=0.5 W=0.9 AD=0.5625 PD=2.15 AS=2.565 PS=7.5
M1100 GND 68 299 GND MN L=0.5 W=0.9 AD=0.5625 PD=2.15 AS=2.565 PS=7.5
M1101 GND 69 300 GND MN L=0.5 W=0.9 AD=0.5625 PD=2.15 AS=2.565 PS=7.5
M1102 GND 70 301 GND MN L=0.5 W=0.9 AD=0.5625 PD=2.15 AS=2.565 PS=7.5
M1103 63 54 647 GND MN L=0.5 W=0.9 AD=0.2475 PD=1.45 AS=1.125 PS=4.3
M1104 64 55 648 GND MN L=0.5 W=0.9 AD=0.495 PD=2.9 AS=0.5625 PS=2.15
M1105 65 56 649 GND MN L=0.5 W=0.9 AD=0.495 PD=2.9 AS=0.5625 PS=2.15
M1106 66 57 650 GND MN L=0.5 W=0.9 AD=0.495 PD=2.9 AS=0.5625 PS=2.15
M1107 67 58 651 GND MN L=0.5 W=0.9 AD=0.495 PD=2.9 AS=0.5625 PS=2.15
M1108 68 59 652 GND MN L=0.5 W=0.9 AD=0.495 PD=2.9 AS=0.5625 PS=2.15
M1109 69 60 653 GND MN L=0.5 W=0.9 AD=0.495 PD=2.9 AS=0.5625 PS=2.15
M1110 70 61 654 GND MN L=0.5 W=0.9 AD=0.495 PD=2.9 AS=0.5625 PS=2.15
M1111 GND 302 63 GND MN L=0.5 W=0.9 AD=1.125 PD=4.3 AS=1.2825 PS=3.75
M1112 GND 303 64 GND MN L=0.5 W=0.9 AD=0.5625 PD=2.15 AS=2.565 PS=7.5
M1113 GND 304 65 GND MN L=0.5 W=0.9 AD=0.5625 PD=2.15 AS=2.565 PS=7.5
M1114 GND 305 66 GND MN L=0.5 W=0.9 AD=0.5625 PD=2.15 AS=2.565 PS=7.5
M1115 GND 306 67 GND MN L=0.5 W=0.9 AD=0.5625 PD=2.15 AS=2.565 PS=7.5
M1116 GND 307 68 GND MN L=0.5 W=0.9 AD=0.5625 PD=2.15 AS=2.565 PS=7.5
M1117 GND 308 69 GND MN L=0.5 W=0.9 AD=0.5625 PD=2.15 AS=2.565 PS=7.5
M1118 GND 309 70 GND MN L=0.5 W=0.9 AD=0.5625 PD=2.15 AS=2.565 PS=7.5
M1119 319 63 GND GND MN L=0.5 W=0.9 AD=0.495 PD=2 AS=0.945 PS=3.9
M1120 320 64 GND GND MN L=0.5 W=0.9 AD=0.99 PD=4 AS=0.945 PS=3.9
M1121 321 65 GND GND MN L=0.5 W=0.9 AD=0.99 PD=4 AS=0.945 PS=3.9
M1122 322 66 GND GND MN L=0.5 W=0.9 AD=0.99 PD=4 AS=0.945 PS=3.9
M1123 323 67 GND GND MN L=0.5 W=0.9 AD=0.99 PD=4 AS=0.945 PS=3.9
M1124 324 68 GND GND MN L=0.5 W=0.9 AD=0.99 PD=4 AS=0.945 PS=3.9
M1125 325 69 GND GND MN L=0.5 W=0.9 AD=0.99 PD=4 AS=0.945 PS=3.9
M1126 326 70 GND GND MN L=0.5 W=0.9 AD=0.99 PD=4 AS=0.945 PS=3.9
M1127 GND 327 45 GND MN L=0.5 W=0.9 AD=0.945 PD=3.9 AS=0.9675 PS=3.05
M1128 GND 328 54 GND MN L=0.5 W=0.9 AD=0.945 PD=3.9 AS=0.9675 PS=3.05
M1129 GND 329 55 GND MN L=0.5 W=0.9 AD=0.945 PD=3.9 AS=0.9675 PS=3.05
M1130 GND 330 56 GND MN L=0.5 W=0.9 AD=0.945 PD=3.9 AS=0.9675 PS=3.05
M1131 GND 331 57 GND MN L=0.5 W=0.9 AD=0.945 PD=3.9 AS=0.9675 PS=3.05
M1132 GND 332 58 GND MN L=0.5 W=0.9 AD=0.945 PD=3.9 AS=0.9675 PS=3.05
M1133 GND 333 59 GND MN L=0.5 W=0.9 AD=0.945 PD=3.9 AS=0.9675 PS=3.05
M1134 GND 334 60 GND MN L=0.5 W=0.9 AD=0.945 PD=3.9 AS=0.9675 PS=3.05
M1135 655 27 GND GND MN L=0.5 W=0.9 AD=0.9675 PD=3.05 AS=0.495 PS=2.9
M1136 656 28 GND GND MN L=0.5 W=0.9 AD=1.935 PD=6.1 AS=0.2475 PS=1.45
M1137 657 29 GND GND MN L=0.5 W=0.9 AD=1.935 PD=6.1 AS=0.2475 PS=1.45
M1138 658 30 GND GND MN L=0.5 W=0.9 AD=1.935 PD=6.1 AS=0.2475 PS=1.45
M1139 659 31 GND GND MN L=0.5 W=0.9 AD=1.935 PD=6.1 AS=0.2475 PS=1.45
M1140 660 32 GND GND MN L=0.5 W=0.9 AD=1.935 PD=6.1 AS=0.2475 PS=1.45
M1141 661 33 GND GND MN L=0.5 W=0.9 AD=1.935 PD=6.1 AS=0.2475 PS=1.45
M1142 662 34 GND GND MN L=0.5 W=0.9 AD=1.935 PD=6.1 AS=0.2475 PS=1.45
M1143 47 319 54 GND MN L=0.5 W=0.9 AD=0.99 PD=4 AS=0.5625 PS=2.15
M1144 48 320 55 GND MN L=0.5 W=0.9 AD=0.99 PD=4 AS=0.5625 PS=2.15
M1145 49 321 56 GND MN L=0.5 W=0.9 AD=0.99 PD=4 AS=0.5625 PS=2.15
M1146 50 322 57 GND MN L=0.5 W=0.9 AD=0.99 PD=4 AS=0.5625 PS=2.15
M1147 51 323 58 GND MN L=0.5 W=0.9 AD=0.99 PD=4 AS=0.5625 PS=2.15
M1148 52 324 59 GND MN L=0.5 W=0.9 AD=0.99 PD=4 AS=0.5625 PS=2.15
M1149 53 325 60 GND MN L=0.5 W=0.9 AD=0.99 PD=4 AS=0.5625 PS=2.15
M1150 P<15> 326 61 GND MN L=0.5 W=0.9 AD=0.99 PD=4 AS=0.5625 PS=2.15
M1151 327 72 655 GND MN L=0.5 W=0.9 AD=0.2475 PD=1.45 AS=0.99 PS=4
M1152 GND 63 47 GND MN L=0.5 W=0.9 AD=0.5625 PD=2.15 AS=0.945 PS=3.9
M1153 47 64 48 GND MN L=0.5 W=0.9 AD=1.125 PD=4.3 AS=0.4725 PS=1.95
M1154 48 65 49 GND MN L=0.5 W=0.9 AD=1.125 PD=4.3 AS=0.4725 PS=1.95
M1155 49 66 50 GND MN L=0.5 W=0.9 AD=1.125 PD=4.3 AS=0.4725 PS=1.95
M1156 50 67 51 GND MN L=0.5 W=0.9 AD=1.125 PD=4.3 AS=0.4725 PS=1.95
M1157 51 68 52 GND MN L=0.5 W=0.9 AD=1.125 PD=4.3 AS=0.4725 PS=1.95
M1158 52 69 53 GND MN L=0.5 W=0.9 AD=1.125 PD=4.3 AS=0.4725 PS=1.95
M1159 53 70 P<15> GND MN L=0.5 W=0.9 AD=1.125 PD=4.3 AS=0.4725 PS=1.95
M1160 328 72 656 GND MN L=0.5 W=0.9 AD=0.2475 PD=1.45 AS=0.99 PS=4
M1161 329 72 657 GND MN L=0.5 W=0.9 AD=0.2475 PD=1.45 AS=0.99 PS=4
M1162 330 72 658 GND MN L=0.5 W=0.9 AD=0.2475 PD=1.45 AS=0.99 PS=4
M1163 331 72 659 GND MN L=0.5 W=0.9 AD=0.2475 PD=1.45 AS=0.99 PS=4
M1164 332 72 660 GND MN L=0.5 W=0.9 AD=0.2475 PD=1.45 AS=0.99 PS=4
M1165 333 72 661 GND MN L=0.5 W=0.9 AD=0.2475 PD=1.45 AS=0.99 PS=4
M1166 334 72 662 GND MN L=0.5 W=0.9 AD=0.2475 PD=1.45 AS=0.99 PS=4
M1167 74 343 GND GND MN L=0.5 W=0.9 AD=1.2825 PD=3.75 AS=1.125 PS=4.3
M1168 75 344 GND GND MN L=0.5 W=0.9 AD=2.565 PD=7.5 AS=0.5625 PS=2.15
M1169 76 345 GND GND MN L=0.5 W=0.9 AD=2.565 PD=7.5 AS=0.5625 PS=2.15
M1170 77 346 GND GND MN L=0.5 W=0.9 AD=2.565 PD=7.5 AS=0.5625 PS=2.15
M1171 78 347 GND GND MN L=0.5 W=0.9 AD=2.565 PD=7.5 AS=0.5625 PS=2.15
M1172 79 348 GND GND MN L=0.5 W=0.9 AD=2.565 PD=7.5 AS=0.5625 PS=2.15
M1173 80 349 GND GND MN L=0.5 W=0.9 AD=2.565 PD=7.5 AS=0.5625 PS=2.15
M1174 P<13> 350 GND GND MN L=0.5 W=0.9 AD=2.565 PD=7.5 AS=0.5625 PS=2.15
M1175 72 367 GND GND MN L=0.5 W=0.9 AD=1.8 PD=5.8 AS=0.5625 PS=2.15
M1176 663 GND 74 GND MN L=0.5 W=0.9 AD=0.5625 PD=2.15 AS=0.495 PS=2.9
M1177 664 82 75 GND MN L=0.5 W=0.9 AD=0.5625 PD=2.15 AS=0.495 PS=2.9
M1178 665 83 76 GND MN L=0.5 W=0.9 AD=0.5625 PD=2.15 AS=0.495 PS=2.9
M1179 666 84 77 GND MN L=0.5 W=0.9 AD=0.5625 PD=2.15 AS=0.495 PS=2.9
M1180 667 85 78 GND MN L=0.5 W=0.9 AD=0.5625 PD=2.15 AS=0.495 PS=2.9
M1181 668 86 79 GND MN L=0.5 W=0.9 AD=0.5625 PD=2.15 AS=0.495 PS=2.9
M1182 669 87 80 GND MN L=0.5 W=0.9 AD=0.5625 PD=2.15 AS=0.495 PS=2.9
M1183 670 88 P<13> GND MN L=0.5 W=0.9 AD=0.5625 PD=2.15 AS=0.495 PS=2.9
M1184 351 45 GND GND MN L=0.5 W=0.9 AD=2.565 PD=7.5 AS=0.5625 PS=2.15
M1185 352 38 GND GND MN L=0.5 W=0.9 AD=2.565 PD=7.5 AS=0.5625 PS=2.15
M1186 353 39 GND GND MN L=0.5 W=0.9 AD=2.565 PD=7.5 AS=0.5625 PS=2.15
M1187 354 40 GND GND MN L=0.5 W=0.9 AD=2.565 PD=7.5 AS=0.5625 PS=2.15
M1188 355 41 GND GND MN L=0.5 W=0.9 AD=2.565 PD=7.5 AS=0.5625 PS=2.15
M1189 356 42 GND GND MN L=0.5 W=0.9 AD=2.565 PD=7.5 AS=0.5625 PS=2.15
M1190 357 43 GND GND MN L=0.5 W=0.9 AD=2.565 PD=7.5 AS=0.5625 PS=2.15
M1191 358 44 GND GND MN L=0.5 W=0.9 AD=2.565 PD=7.5 AS=0.5625 PS=2.15
M1192 GND 367 72 GND MN L=0.5 W=0.9 AD=1.125 PD=4.3 AS=0.9675 PS=3.05
M1193 GND 98 663 GND MN L=0.5 W=0.9 AD=0.495 PD=2.9 AS=0.9675 PS=3.05
M1194 GND 99 664 GND MN L=0.5 W=0.9 AD=0.495 PD=2.9 AS=0.9675 PS=3.05
M1195 GND 100 665 GND MN L=0.5 W=0.9 AD=0.495 PD=2.9 AS=0.9675 PS=3.05
M1196 GND 101 666 GND MN L=0.5 W=0.9 AD=0.495 PD=2.9 AS=0.9675 PS=3.05
M1197 GND 102 667 GND MN L=0.5 W=0.9 AD=0.495 PD=2.9 AS=0.9675 PS=3.05
M1198 GND 103 668 GND MN L=0.5 W=0.9 AD=0.495 PD=2.9 AS=0.9675 PS=3.05
M1199 GND 104 669 GND MN L=0.5 W=0.9 AD=0.495 PD=2.9 AS=0.9675 PS=3.05
M1200 GND 105 670 GND MN L=0.5 W=0.9 AD=0.495 PD=2.9 AS=0.9675 PS=3.05
M1201 GND 90 351 GND MN L=0.5 W=0.9 AD=0.5625 PD=2.15 AS=1.935 PS=6.1
M1202 GND 91 352 GND MN L=0.5 W=0.9 AD=0.5625 PD=2.15 AS=1.935 PS=6.1
M1203 GND 92 353 GND MN L=0.5 W=0.9 AD=0.5625 PD=2.15 AS=1.935 PS=6.1
M1204 GND 93 354 GND MN L=0.5 W=0.9 AD=0.5625 PD=2.15 AS=1.935 PS=6.1
M1205 GND 94 355 GND MN L=0.5 W=0.9 AD=0.5625 PD=2.15 AS=1.935 PS=6.1
M1206 GND 95 356 GND MN L=0.5 W=0.9 AD=0.5625 PD=2.15 AS=1.935 PS=6.1
M1207 GND 96 357 GND MN L=0.5 W=0.9 AD=0.5625 PD=2.15 AS=1.935 PS=6.1
M1208 GND 89 358 GND MN L=0.5 W=0.9 AD=0.5625 PD=2.15 AS=1.935 PS=6.1
M1209 367 A<6> GND GND MN L=0.5 W=0.9 AD=0.9675 PD=3.05 AS=0.99 PS=4
M1210 671 45 GND GND MN L=0.5 W=0.9 AD=1.935 PD=6.1 AS=0.2475 PS=1.45
M1211 672 38 GND GND MN L=0.5 W=0.9 AD=1.935 PD=6.1 AS=0.2475 PS=1.45
M1212 673 39 GND GND MN L=0.5 W=0.9 AD=1.935 PD=6.1 AS=0.2475 PS=1.45
M1213 674 40 GND GND MN L=0.5 W=0.9 AD=1.935 PD=6.1 AS=0.2475 PS=1.45
M1214 675 41 GND GND MN L=0.5 W=0.9 AD=1.935 PD=6.1 AS=0.2475 PS=1.45
M1215 676 42 GND GND MN L=0.5 W=0.9 AD=1.935 PD=6.1 AS=0.2475 PS=1.45
M1216 677 43 GND GND MN L=0.5 W=0.9 AD=1.935 PD=6.1 AS=0.2475 PS=1.45
M1217 678 44 GND GND MN L=0.5 W=0.9 AD=1.935 PD=6.1 AS=0.2475 PS=1.45
M1218 343 GND GND GND MN L=0.5 W=0.9 AD=0.9675 PD=3.05 AS=1.125 PS=4.3
M1219 344 82 GND GND MN L=0.5 W=0.9 AD=0.9675 PD=3.05 AS=1.125 PS=4.3
M1220 345 83 GND GND MN L=0.5 W=0.9 AD=0.9675 PD=3.05 AS=1.125 PS=4.3
M1221 346 84 GND GND MN L=0.5 W=0.9 AD=0.9675 PD=3.05 AS=1.125 PS=4.3
M1222 347 85 GND GND MN L=0.5 W=0.9 AD=0.9675 PD=3.05 AS=1.125 PS=4.3
M1223 348 86 GND GND MN L=0.5 W=0.9 AD=0.9675 PD=3.05 AS=1.125 PS=4.3
M1224 349 87 GND GND MN L=0.5 W=0.9 AD=0.9675 PD=3.05 AS=1.125 PS=4.3
M1225 350 88 GND GND MN L=0.5 W=0.9 AD=0.9675 PD=3.05 AS=1.125 PS=4.3
M1226 GND 98 343 GND MN L=0.5 W=0.9 AD=0.5625 PD=2.15 AS=2.565 PS=7.5
M1227 GND 99 344 GND MN L=0.5 W=0.9 AD=0.5625 PD=2.15 AS=2.565 PS=7.5
M1228 GND 100 345 GND MN L=0.5 W=0.9 AD=0.5625 PD=2.15 AS=2.565 PS=7.5
M1229 GND 101 346 GND MN L=0.5 W=0.9 AD=0.5625 PD=2.15 AS=2.565 PS=7.5
M1230 GND 102 347 GND MN L=0.5 W=0.9 AD=0.5625 PD=2.15 AS=2.565 PS=7.5
M1231 GND 103 348 GND MN L=0.5 W=0.9 AD=0.5625 PD=2.15 AS=2.565 PS=7.5
M1232 GND 104 349 GND MN L=0.5 W=0.9 AD=0.5625 PD=2.15 AS=2.565 PS=7.5
M1233 GND 105 350 GND MN L=0.5 W=0.9 AD=0.5625 PD=2.15 AS=2.565 PS=7.5
M1234 98 90 671 GND MN L=0.5 W=0.9 AD=0.2475 PD=1.45 AS=1.125 PS=4.3
M1235 99 91 672 GND MN L=0.5 W=0.9 AD=0.2475 PD=1.45 AS=1.125 PS=4.3
M1236 100 92 673 GND MN L=0.5 W=0.9 AD=0.2475 PD=1.45 AS=1.125 PS=4.3
M1237 101 93 674 GND MN L=0.5 W=0.9 AD=0.2475 PD=1.45 AS=1.125 PS=4.3
M1238 102 94 675 GND MN L=0.5 W=0.9 AD=0.2475 PD=1.45 AS=1.125 PS=4.3
M1239 103 95 676 GND MN L=0.5 W=0.9 AD=0.2475 PD=1.45 AS=1.125 PS=4.3
M1240 104 96 677 GND MN L=0.5 W=0.9 AD=0.2475 PD=1.45 AS=1.125 PS=4.3
M1241 105 89 678 GND MN L=0.5 W=0.9 AD=0.2475 PD=1.45 AS=1.125 PS=4.3
M1242 GND 351 98 GND MN L=0.5 W=0.9 AD=1.125 PD=4.3 AS=1.2825 PS=3.75
M1243 GND 352 99 GND MN L=0.5 W=0.9 AD=0.5625 PD=2.15 AS=2.565 PS=7.5
M1244 GND 353 100 GND MN L=0.5 W=0.9 AD=0.5625 PD=2.15 AS=2.565 PS=7.5
M1245 GND 354 101 GND MN L=0.5 W=0.9 AD=0.5625 PD=2.15 AS=2.565 PS=7.5
M1246 GND 355 102 GND MN L=0.5 W=0.9 AD=0.5625 PD=2.15 AS=2.565 PS=7.5
M1247 GND 356 103 GND MN L=0.5 W=0.9 AD=0.5625 PD=2.15 AS=2.565 PS=7.5
M1248 GND 357 104 GND MN L=0.5 W=0.9 AD=0.5625 PD=2.15 AS=2.565 PS=7.5
M1249 GND 358 105 GND MN L=0.5 W=0.9 AD=0.5625 PD=2.15 AS=2.565 PS=7.5
M1250 368 98 GND GND MN L=0.5 W=0.9 AD=0.99 PD=4 AS=0.4725 PS=1.95
M1251 369 99 GND GND MN L=0.5 W=0.9 AD=0.495 PD=2 AS=0.945 PS=3.9
M1252 370 100 GND GND MN L=0.5 W=0.9 AD=0.495 PD=2 AS=0.945 PS=3.9
M1253 371 101 GND GND MN L=0.5 W=0.9 AD=0.495 PD=2 AS=0.945 PS=3.9
M1254 372 102 GND GND MN L=0.5 W=0.9 AD=0.495 PD=2 AS=0.945 PS=3.9
M1255 373 103 GND GND MN L=0.5 W=0.9 AD=0.495 PD=2 AS=0.945 PS=3.9
M1256 374 104 GND GND MN L=0.5 W=0.9 AD=0.495 PD=2 AS=0.945 PS=3.9
M1257 375 105 GND GND MN L=0.5 W=0.9 AD=0.495 PD=2 AS=0.945 PS=3.9
M1258 GND 376 81 GND MN L=0.5 W=0.9 AD=0.4725 PD=1.95 AS=1.935 PS=6.1
M1259 679 27 GND GND MN L=0.5 W=0.9 AD=0.9675 PD=3.05 AS=0.495 PS=2.9
M1260 GND 377 90 GND MN L=0.5 W=0.9 AD=0.945 PD=3.9 AS=0.9675 PS=3.05
M1261 GND 378 91 GND MN L=0.5 W=0.9 AD=0.945 PD=3.9 AS=0.9675 PS=3.05
M1262 GND 379 92 GND MN L=0.5 W=0.9 AD=0.945 PD=3.9 AS=0.9675 PS=3.05
M1263 GND 380 93 GND MN L=0.5 W=0.9 AD=0.945 PD=3.9 AS=0.9675 PS=3.05
M1264 GND 381 94 GND MN L=0.5 W=0.9 AD=0.945 PD=3.9 AS=0.9675 PS=3.05
M1265 GND 382 95 GND MN L=0.5 W=0.9 AD=0.945 PD=3.9 AS=0.9675 PS=3.05
M1266 GND 383 96 GND MN L=0.5 W=0.9 AD=0.945 PD=3.9 AS=0.9675 PS=3.05
M1267 376 106 679 GND MN L=0.5 W=0.9 AD=0.2475 PD=1.45 AS=0.99 PS=4
M1268 680 28 GND GND MN L=0.5 W=0.9 AD=1.935 PD=6.1 AS=0.2475 PS=1.45
M1269 681 29 GND GND MN L=0.5 W=0.9 AD=0.9675 PD=3.05 AS=0.495 PS=2.9
M1270 682 30 GND GND MN L=0.5 W=0.9 AD=0.9675 PD=3.05 AS=0.495 PS=2.9
M1271 683 31 GND GND MN L=0.5 W=0.9 AD=0.9675 PD=3.05 AS=0.495 PS=2.9
M1272 684 32 GND GND MN L=0.5 W=0.9 AD=0.9675 PD=3.05 AS=0.495 PS=2.9
M1273 685 33 GND GND MN L=0.5 W=0.9 AD=0.9675 PD=3.05 AS=0.495 PS=2.9
M1274 686 34 GND GND MN L=0.5 W=0.9 AD=0.9675 PD=3.05 AS=0.495 PS=2.9
M1275 82 368 90 GND MN L=0.5 W=0.9 AD=0.99 PD=4 AS=0.5625 PS=2.15
M1276 83 369 91 GND MN L=0.5 W=0.9 AD=0.99 PD=4 AS=0.5625 PS=2.15
M1277 84 370 92 GND MN L=0.5 W=0.9 AD=0.99 PD=4 AS=0.5625 PS=2.15
M1278 85 371 93 GND MN L=0.5 W=0.9 AD=0.99 PD=4 AS=0.5625 PS=2.15
M1279 86 372 94 GND MN L=0.5 W=0.9 AD=0.99 PD=4 AS=0.5625 PS=2.15
M1280 87 373 95 GND MN L=0.5 W=0.9 AD=0.99 PD=4 AS=0.5625 PS=2.15
M1281 88 374 96 GND MN L=0.5 W=0.9 AD=0.99 PD=4 AS=0.5625 PS=2.15
M1282 61 375 89 GND MN L=0.5 W=0.9 AD=0.99 PD=4 AS=0.5625 PS=2.15
M1283 GND 98 82 GND MN L=0.5 W=0.9 AD=0.5625 PD=2.15 AS=0.945 PS=3.9
M1284 82 99 83 GND MN L=0.5 W=0.9 AD=1.125 PD=4.3 AS=0.4725 PS=1.95
M1285 83 100 84 GND MN L=0.5 W=0.9 AD=1.125 PD=4.3 AS=0.4725 PS=1.95
M1286 84 101 85 GND MN L=0.5 W=0.9 AD=1.125 PD=4.3 AS=0.4725 PS=1.95
M1287 85 102 86 GND MN L=0.5 W=0.9 AD=1.125 PD=4.3 AS=0.4725 PS=1.95
M1288 86 103 87 GND MN L=0.5 W=0.9 AD=1.125 PD=4.3 AS=0.4725 PS=1.95
M1289 87 104 88 GND MN L=0.5 W=0.9 AD=1.125 PD=4.3 AS=0.4725 PS=1.95
M1290 88 105 61 GND MN L=0.5 W=0.9 AD=1.125 PD=4.3 AS=0.4725 PS=1.95
M1291 377 106 680 GND MN L=0.5 W=0.9 AD=0.2475 PD=1.45 AS=0.99 PS=4
M1292 378 106 681 GND MN L=0.5 W=0.9 AD=0.2475 PD=1.45 AS=0.99 PS=4
M1293 379 106 682 GND MN L=0.5 W=0.9 AD=0.2475 PD=1.45 AS=0.99 PS=4
M1294 380 106 683 GND MN L=0.5 W=0.9 AD=0.2475 PD=1.45 AS=0.99 PS=4
M1295 381 106 684 GND MN L=0.5 W=0.9 AD=0.2475 PD=1.45 AS=0.99 PS=4
M1296 382 106 685 GND MN L=0.5 W=0.9 AD=0.2475 PD=1.45 AS=0.99 PS=4
M1297 383 106 686 GND MN L=0.5 W=0.9 AD=0.2475 PD=1.45 AS=0.99 PS=4
M1298 106 408 GND GND MN L=0.5 W=0.9 AD=1.8 PD=5.8 AS=0.5625 PS=2.15
M1299 108 392 GND GND MN L=0.5 W=0.9 AD=2.565 PD=7.5 AS=0.5625 PS=2.15
M1300 109 393 GND GND MN L=0.5 W=0.9 AD=2.565 PD=7.5 AS=0.5625 PS=2.15
M1301 110 394 GND GND MN L=0.5 W=0.9 AD=1.2825 PD=3.75 AS=1.125 PS=4.3
M1302 111 395 GND GND MN L=0.5 W=0.9 AD=1.2825 PD=3.75 AS=1.125 PS=4.3
M1303 112 396 GND GND MN L=0.5 W=0.9 AD=1.2825 PD=3.75 AS=1.125 PS=4.3
M1304 113 397 GND GND MN L=0.5 W=0.9 AD=1.2825 PD=3.75 AS=1.125 PS=4.3
M1305 114 398 GND GND MN L=0.5 W=0.9 AD=1.2825 PD=3.75 AS=1.125 PS=4.3
M1306 P<12> 399 GND GND MN L=0.5 W=0.9 AD=1.2825 PD=3.75 AS=1.125 PS=4.3
M1307 GND 408 106 GND MN L=0.5 W=0.9 AD=0.5625 PD=2.15 AS=1.935 PS=6.1
M1308 687 GND 108 GND MN L=0.5 W=0.9 AD=0.5625 PD=2.15 AS=0.495 PS=2.9
M1309 688 116 109 GND MN L=0.5 W=0.9 AD=0.5625 PD=2.15 AS=0.495 PS=2.9
M1310 689 117 110 GND MN L=0.5 W=0.9 AD=0.5625 PD=2.15 AS=0.495 PS=2.9
M1311 690 118 111 GND MN L=0.5 W=0.9 AD=0.5625 PD=2.15 AS=0.495 PS=2.9
M1312 691 119 112 GND MN L=0.5 W=0.9 AD=0.5625 PD=2.15 AS=0.495 PS=2.9
M1313 692 120 113 GND MN L=0.5 W=0.9 AD=0.5625 PD=2.15 AS=0.495 PS=2.9
M1314 693 121 114 GND MN L=0.5 W=0.9 AD=0.5625 PD=2.15 AS=0.495 PS=2.9
M1315 694 122 P<12> GND MN L=0.5 W=0.9 AD=0.5625 PD=2.15 AS=0.495 PS=2.9
M1316 400 81 GND GND MN L=0.5 W=0.9 AD=1.2825 PD=3.75 AS=1.125 PS=4.3
M1317 401 74 GND GND MN L=0.5 W=0.9 AD=1.2825 PD=3.75 AS=1.125 PS=4.3
M1318 402 75 GND GND MN L=0.5 W=0.9 AD=1.2825 PD=3.75 AS=1.125 PS=4.3
M1319 403 76 GND GND MN L=0.5 W=0.9 AD=1.2825 PD=3.75 AS=1.125 PS=4.3
M1320 404 77 GND GND MN L=0.5 W=0.9 AD=1.2825 PD=3.75 AS=1.125 PS=4.3
M1321 405 78 GND GND MN L=0.5 W=0.9 AD=1.2825 PD=3.75 AS=1.125 PS=4.3
M1322 406 79 GND GND MN L=0.5 W=0.9 AD=1.2825 PD=3.75 AS=1.125 PS=4.3
M1323 407 80 GND GND MN L=0.5 W=0.9 AD=1.2825 PD=3.75 AS=1.125 PS=4.3
M1324 408 A<5> GND GND MN L=0.5 W=0.9 AD=0.9675 PD=3.05 AS=0.99 PS=4
M1325 GND 132 687 GND MN L=0.5 W=0.9 AD=0.2475 PD=1.45 AS=1.935 PS=6.1
M1326 GND 133 688 GND MN L=0.5 W=0.9 AD=0.2475 PD=1.45 AS=1.935 PS=6.1
M1327 GND 134 689 GND MN L=0.5 W=0.9 AD=0.2475 PD=1.45 AS=1.935 PS=6.1
M1328 GND 135 690 GND MN L=0.5 W=0.9 AD=0.2475 PD=1.45 AS=1.935 PS=6.1
M1329 GND 136 691 GND MN L=0.5 W=0.9 AD=0.2475 PD=1.45 AS=1.935 PS=6.1
M1330 GND 137 692 GND MN L=0.5 W=0.9 AD=0.2475 PD=1.45 AS=1.935 PS=6.1
M1331 GND 138 693 GND MN L=0.5 W=0.9 AD=0.495 PD=2.9 AS=0.9675 PS=3.05
M1332 GND 139 694 GND MN L=0.5 W=0.9 AD=0.495 PD=2.9 AS=0.9675 PS=3.05
M1333 GND 123 400 GND MN L=0.5 W=0.9 AD=1.125 PD=4.3 AS=0.9675 PS=3.05
M1334 GND 124 401 GND MN L=0.5 W=0.9 AD=1.125 PD=4.3 AS=0.9675 PS=3.05
M1335 GND 125 402 GND MN L=0.5 W=0.9 AD=1.125 PD=4.3 AS=0.9675 PS=3.05
M1336 GND 126 403 GND MN L=0.5 W=0.9 AD=1.125 PD=4.3 AS=0.9675 PS=3.05
M1337 GND 127 404 GND MN L=0.5 W=0.9 AD=1.125 PD=4.3 AS=0.9675 PS=3.05
M1338 GND 128 405 GND MN L=0.5 W=0.9 AD=1.125 PD=4.3 AS=0.9675 PS=3.05
M1339 GND 129 406 GND MN L=0.5 W=0.9 AD=1.125 PD=4.3 AS=0.9675 PS=3.05
M1340 GND 130 407 GND MN L=0.5 W=0.9 AD=1.125 PD=4.3 AS=0.9675 PS=3.05
M1341 695 81 GND GND MN L=0.5 W=0.9 AD=0.9675 PD=3.05 AS=0.495 PS=2.9
M1342 696 74 GND GND MN L=0.5 W=0.9 AD=0.9675 PD=3.05 AS=0.495 PS=2.9
M1343 697 75 GND GND MN L=0.5 W=0.9 AD=0.9675 PD=3.05 AS=0.495 PS=2.9
M1344 698 76 GND GND MN L=0.5 W=0.9 AD=0.9675 PD=3.05 AS=0.495 PS=2.9
M1345 699 77 GND GND MN L=0.5 W=0.9 AD=0.9675 PD=3.05 AS=0.495 PS=2.9
M1346 700 78 GND GND MN L=0.5 W=0.9 AD=0.9675 PD=3.05 AS=0.495 PS=2.9
M1347 701 79 GND GND MN L=0.5 W=0.9 AD=0.9675 PD=3.05 AS=0.495 PS=2.9
M1348 702 80 GND GND MN L=0.5 W=0.9 AD=0.9675 PD=3.05 AS=0.495 PS=2.9
M1349 392 GND GND GND MN L=0.5 W=0.9 AD=0.9675 PD=3.05 AS=1.125 PS=4.3
M1350 393 116 GND GND MN L=0.5 W=0.9 AD=0.9675 PD=3.05 AS=1.125 PS=4.3
M1351 394 117 GND GND MN L=0.5 W=0.9 AD=0.9675 PD=3.05 AS=1.125 PS=4.3
M1352 395 118 GND GND MN L=0.5 W=0.9 AD=0.9675 PD=3.05 AS=1.125 PS=4.3
M1353 396 119 GND GND MN L=0.5 W=0.9 AD=0.9675 PD=3.05 AS=1.125 PS=4.3
M1354 397 120 GND GND MN L=0.5 W=0.9 AD=0.9675 PD=3.05 AS=1.125 PS=4.3
M1355 398 121 GND GND MN L=0.5 W=0.9 AD=0.9675 PD=3.05 AS=1.125 PS=4.3
M1356 399 122 GND GND MN L=0.5 W=0.9 AD=0.9675 PD=3.05 AS=1.125 PS=4.3
M1357 GND 132 392 GND MN L=0.5 W=0.9 AD=1.125 PD=4.3 AS=1.2825 PS=3.75
M1358 GND 133 393 GND MN L=0.5 W=0.9 AD=1.125 PD=4.3 AS=1.2825 PS=3.75
M1359 GND 134 394 GND MN L=0.5 W=0.9 AD=1.125 PD=4.3 AS=1.2825 PS=3.75
M1360 GND 135 395 GND MN L=0.5 W=0.9 AD=1.125 PD=4.3 AS=1.2825 PS=3.75
M1361 GND 136 396 GND MN L=0.5 W=0.9 AD=1.125 PD=4.3 AS=1.2825 PS=3.75
M1362 GND 137 397 GND MN L=0.5 W=0.9 AD=1.125 PD=4.3 AS=1.2825 PS=3.75
M1363 GND 138 398 GND MN L=0.5 W=0.9 AD=1.125 PD=4.3 AS=1.2825 PS=3.75
M1364 GND 139 399 GND MN L=0.5 W=0.9 AD=1.125 PD=4.3 AS=1.2825 PS=3.75
M1365 132 123 695 GND MN L=0.5 W=0.9 AD=0.2475 PD=1.45 AS=1.125 PS=4.3
M1366 133 124 696 GND MN L=0.5 W=0.9 AD=0.2475 PD=1.45 AS=1.125 PS=4.3
M1367 134 125 697 GND MN L=0.5 W=0.9 AD=0.2475 PD=1.45 AS=1.125 PS=4.3
M1368 135 126 698 GND MN L=0.5 W=0.9 AD=0.2475 PD=1.45 AS=1.125 PS=4.3
M1369 136 127 699 GND MN L=0.5 W=0.9 AD=0.2475 PD=1.45 AS=1.125 PS=4.3
M1370 137 128 700 GND MN L=0.5 W=0.9 AD=0.2475 PD=1.45 AS=1.125 PS=4.3
M1371 138 129 701 GND MN L=0.5 W=0.9 AD=0.2475 PD=1.45 AS=1.125 PS=4.3
M1372 139 130 702 GND MN L=0.5 W=0.9 AD=0.2475 PD=1.45 AS=1.125 PS=4.3
M1373 GND 400 132 GND MN L=0.5 W=0.9 AD=0.5625 PD=2.15 AS=2.565 PS=7.5
M1374 GND 401 133 GND MN L=0.5 W=0.9 AD=0.5625 PD=2.15 AS=2.565 PS=7.5
M1375 GND 402 134 GND MN L=0.5 W=0.9 AD=0.5625 PD=2.15 AS=2.565 PS=7.5
M1376 GND 403 135 GND MN L=0.5 W=0.9 AD=0.5625 PD=2.15 AS=2.565 PS=7.5
M1377 GND 404 136 GND MN L=0.5 W=0.9 AD=0.5625 PD=2.15 AS=2.565 PS=7.5
M1378 GND 405 137 GND MN L=0.5 W=0.9 AD=0.5625 PD=2.15 AS=2.565 PS=7.5
M1379 GND 406 138 GND MN L=0.5 W=0.9 AD=0.5625 PD=2.15 AS=2.565 PS=7.5
M1380 GND 407 139 GND MN L=0.5 W=0.9 AD=0.5625 PD=2.15 AS=2.565 PS=7.5
M1381 GND 417 115 GND MN L=0.5 W=0.9 AD=0.945 PD=3.9 AS=0.9675 PS=3.05
M1382 703 27 GND GND MN L=0.5 W=0.9 AD=0.9675 PD=3.05 AS=0.495 PS=2.9
M1383 418 132 GND GND MN L=0.5 W=0.9 AD=0.495 PD=2 AS=0.945 PS=3.9
M1384 419 133 GND GND MN L=0.5 W=0.9 AD=0.495 PD=2 AS=0.945 PS=3.9
M1385 420 134 GND GND MN L=0.5 W=0.9 AD=0.495 PD=2 AS=0.945 PS=3.9
M1386 421 135 GND GND MN L=0.5 W=0.9 AD=0.495 PD=2 AS=0.945 PS=3.9
M1387 422 136 GND GND MN L=0.5 W=0.9 AD=0.495 PD=2 AS=0.945 PS=3.9
M1388 423 137 GND GND MN L=0.5 W=0.9 AD=0.495 PD=2 AS=0.945 PS=3.9
M1389 424 138 GND GND MN L=0.5 W=0.9 AD=0.495 PD=2 AS=0.945 PS=3.9
M1390 425 139 GND GND MN L=0.5 W=0.9 AD=0.99 PD=4 AS=0.4725 PS=1.95
M1391 417 140 703 GND MN L=0.5 W=0.9 AD=0.495 PD=2.9 AS=0.495 PS=2
M1392 GND 426 123 GND MN L=0.5 W=0.9 AD=0.4725 PD=1.95 AS=1.935 PS=6.1
M1393 GND 427 124 GND MN L=0.5 W=0.9 AD=0.4725 PD=1.95 AS=1.935 PS=6.1
M1394 GND 428 125 GND MN L=0.5 W=0.9 AD=0.4725 PD=1.95 AS=1.935 PS=6.1
M1395 GND 429 126 GND MN L=0.5 W=0.9 AD=0.4725 PD=1.95 AS=1.935 PS=6.1
M1396 GND 430 127 GND MN L=0.5 W=0.9 AD=0.4725 PD=1.95 AS=1.935 PS=6.1
M1397 GND 431 128 GND MN L=0.5 W=0.9 AD=0.4725 PD=1.95 AS=1.935 PS=6.1
M1398 GND 432 129 GND MN L=0.5 W=0.9 AD=0.4725 PD=1.95 AS=1.935 PS=6.1
M1399 704 28 GND GND MN L=0.5 W=0.9 AD=0.9675 PD=3.05 AS=0.495 PS=2.9
M1400 705 29 GND GND MN L=0.5 W=0.9 AD=0.9675 PD=3.05 AS=0.495 PS=2.9
M1401 706 30 GND GND MN L=0.5 W=0.9 AD=0.9675 PD=3.05 AS=0.495 PS=2.9
M1402 707 31 GND GND MN L=0.5 W=0.9 AD=0.9675 PD=3.05 AS=0.495 PS=2.9
M1403 708 32 GND GND MN L=0.5 W=0.9 AD=0.9675 PD=3.05 AS=0.495 PS=2.9
M1404 709 33 GND GND MN L=0.5 W=0.9 AD=0.9675 PD=3.05 AS=0.495 PS=2.9
M1405 710 34 GND GND MN L=0.5 W=0.9 AD=0.9675 PD=3.05 AS=0.495 PS=2.9
M1406 116 418 123 GND MN L=0.5 W=0.9 AD=0.495 PD=2 AS=1.125 PS=4.3
M1407 117 419 124 GND MN L=0.5 W=0.9 AD=0.495 PD=2 AS=1.125 PS=4.3
M1408 118 420 125 GND MN L=0.5 W=0.9 AD=0.495 PD=2 AS=1.125 PS=4.3
M1409 119 421 126 GND MN L=0.5 W=0.9 AD=0.495 PD=2 AS=1.125 PS=4.3
M1410 120 422 127 GND MN L=0.5 W=0.9 AD=0.495 PD=2 AS=1.125 PS=4.3
M1411 121 423 128 GND MN L=0.5 W=0.9 AD=0.495 PD=2 AS=1.125 PS=4.3
M1412 122 424 129 GND MN L=0.5 W=0.9 AD=0.99 PD=4 AS=0.5625 PS=2.15
M1413 89 425 130 GND MN L=0.5 W=0.9 AD=0.99 PD=4 AS=0.5625 PS=2.15
M1414 GND 132 116 GND MN L=0.5 W=0.9 AD=0.5625 PD=2.15 AS=0.945 PS=3.9
M1415 116 133 117 GND MN L=0.5 W=0.9 AD=0.5625 PD=2.15 AS=0.945 PS=3.9
M1416 117 134 118 GND MN L=0.5 W=0.9 AD=1.125 PD=4.3 AS=0.4725 PS=1.95
M1417 118 135 119 GND MN L=0.5 W=0.9 AD=0.5625 PD=2.15 AS=0.945 PS=3.9
M1418 119 136 120 GND MN L=0.5 W=0.9 AD=0.5625 PD=2.15 AS=0.945 PS=3.9
M1419 120 137 121 GND MN L=0.5 W=0.9 AD=0.5625 PD=2.15 AS=0.945 PS=3.9
M1420 121 138 122 GND MN L=0.5 W=0.9 AD=0.5625 PD=2.15 AS=0.945 PS=3.9
M1421 122 139 89 GND MN L=0.5 W=0.9 AD=0.5625 PD=2.15 AS=0.945 PS=3.9
M1422 426 140 704 GND MN L=0.5 W=0.9 AD=0.2475 PD=1.45 AS=0.99 PS=4
M1423 427 140 705 GND MN L=0.5 W=0.9 AD=0.2475 PD=1.45 AS=0.99 PS=4
M1424 428 140 706 GND MN L=0.5 W=0.9 AD=0.2475 PD=1.45 AS=0.99 PS=4
M1425 429 140 707 GND MN L=0.5 W=0.9 AD=0.2475 PD=1.45 AS=0.99 PS=4
M1426 430 140 708 GND MN L=0.5 W=0.9 AD=0.2475 PD=1.45 AS=0.99 PS=4
M1427 431 140 709 GND MN L=0.5 W=0.9 AD=0.2475 PD=1.45 AS=0.99 PS=4
M1428 432 140 710 GND MN L=0.5 W=0.9 AD=0.2475 PD=1.45 AS=0.99 PS=4
M1429 140 433 GND GND MN L=0.5 W=0.9 AD=1.8 PD=5.8 AS=0.5625 PS=2.15
M1430 GND 433 140 GND MN L=0.5 W=0.9 AD=1.125 PD=4.3 AS=0.9675 PS=3.05
M1431 142 442 GND GND MN L=0.5 W=0.9 AD=2.565 PD=7.5 AS=0.5625 PS=2.15
M1432 143 443 GND GND MN L=0.5 W=0.9 AD=2.565 PD=7.5 AS=0.5625 PS=2.15
M1433 144 444 GND GND MN L=0.5 W=0.9 AD=1.2825 PD=3.75 AS=1.125 PS=4.3
M1434 145 445 GND GND MN L=0.5 W=0.9 AD=1.2825 PD=3.75 AS=1.125 PS=4.3
M1435 146 446 GND GND MN L=0.5 W=0.9 AD=1.2825 PD=3.75 AS=1.125 PS=4.3
M1436 147 447 GND GND MN L=0.5 W=0.9 AD=1.2825 PD=3.75 AS=1.125 PS=4.3
M1437 148 448 GND GND MN L=0.5 W=0.9 AD=1.2825 PD=3.75 AS=1.125 PS=4.3
M1438 P<11> 449 GND GND MN L=0.5 W=0.9 AD=1.2825 PD=3.75 AS=1.125 PS=4.3
M1439 433 A<4> GND GND MN L=0.5 W=0.9 AD=0.9675 PD=3.05 AS=0.99 PS=4
M1440 711 GND 142 GND MN L=0.5 W=0.9 AD=0.5625 PD=2.15 AS=0.495 PS=2.9
M1441 712 150 143 GND MN L=0.5 W=0.9 AD=0.5625 PD=2.15 AS=0.495 PS=2.9
M1442 713 151 144 GND MN L=0.5 W=0.9 AD=0.5625 PD=2.15 AS=0.495 PS=2.9
M1443 714 152 145 GND MN L=0.5 W=0.9 AD=0.5625 PD=2.15 AS=0.495 PS=2.9
M1444 715 153 146 GND MN L=0.5 W=0.9 AD=0.5625 PD=2.15 AS=0.495 PS=2.9
M1445 716 154 147 GND MN L=0.5 W=0.9 AD=0.5625 PD=2.15 AS=0.495 PS=2.9
M1446 717 155 148 GND MN L=0.5 W=0.9 AD=0.5625 PD=2.15 AS=0.495 PS=2.9
M1447 718 156 P<11> GND MN L=0.5 W=0.9 AD=0.5625 PD=2.15 AS=0.495 PS=2.9
M1448 450 115 GND GND MN L=0.5 W=0.9 AD=2.565 PD=7.5 AS=0.5625 PS=2.15
M1449 451 108 GND GND MN L=0.5 W=0.9 AD=2.565 PD=7.5 AS=0.5625 PS=2.15
M1450 452 109 GND GND MN L=0.5 W=0.9 AD=2.565 PD=7.5 AS=0.5625 PS=2.15
M1451 453 110 GND GND MN L=0.5 W=0.9 AD=2.565 PD=7.5 AS=0.5625 PS=2.15
M1452 454 111 GND GND MN L=0.5 W=0.9 AD=2.565 PD=7.5 AS=0.5625 PS=2.15
M1453 455 112 GND GND MN L=0.5 W=0.9 AD=2.565 PD=7.5 AS=0.5625 PS=2.15
M1454 456 113 GND GND MN L=0.5 W=0.9 AD=2.565 PD=7.5 AS=0.5625 PS=2.15
M1455 457 114 GND GND MN L=0.5 W=0.9 AD=2.565 PD=7.5 AS=0.5625 PS=2.15
M1456 GND 166 711 GND MN L=0.5 W=0.9 AD=0.2475 PD=1.45 AS=1.935 PS=6.1
M1457 GND 167 712 GND MN L=0.5 W=0.9 AD=0.2475 PD=1.45 AS=1.935 PS=6.1
M1458 GND 168 713 GND MN L=0.5 W=0.9 AD=0.2475 PD=1.45 AS=1.935 PS=6.1
M1459 GND 169 714 GND MN L=0.5 W=0.9 AD=0.2475 PD=1.45 AS=1.935 PS=6.1
M1460 GND 170 715 GND MN L=0.5 W=0.9 AD=0.2475 PD=1.45 AS=1.935 PS=6.1
M1461 GND 171 716 GND MN L=0.5 W=0.9 AD=0.2475 PD=1.45 AS=1.935 PS=6.1
M1462 GND 172 717 GND MN L=0.5 W=0.9 AD=0.495 PD=2.9 AS=0.9675 PS=3.05
M1463 GND 173 718 GND MN L=0.5 W=0.9 AD=0.2475 PD=1.45 AS=1.935 PS=6.1
M1464 GND 159 450 GND MN L=0.5 W=0.9 AD=0.5625 PD=2.15 AS=1.935 PS=6.1
M1465 GND 160 451 GND MN L=0.5 W=0.9 AD=0.5625 PD=2.15 AS=1.935 PS=6.1
M1466 GND 161 452 GND MN L=0.5 W=0.9 AD=0.5625 PD=2.15 AS=1.935 PS=6.1
M1467 GND 162 453 GND MN L=0.5 W=0.9 AD=0.5625 PD=2.15 AS=1.935 PS=6.1
M1468 GND 163 454 GND MN L=0.5 W=0.9 AD=0.5625 PD=2.15 AS=1.935 PS=6.1
M1469 GND 164 455 GND MN L=0.5 W=0.9 AD=0.5625 PD=2.15 AS=1.935 PS=6.1
M1470 GND 165 456 GND MN L=0.5 W=0.9 AD=0.5625 PD=2.15 AS=1.935 PS=6.1
M1471 GND 158 457 GND MN L=0.5 W=0.9 AD=0.5625 PD=2.15 AS=1.935 PS=6.1
M1472 719 115 GND GND MN L=0.5 W=0.9 AD=0.9675 PD=3.05 AS=0.495 PS=2.9
M1473 720 108 GND GND MN L=0.5 W=0.9 AD=0.9675 PD=3.05 AS=0.495 PS=2.9
M1474 721 109 GND GND MN L=0.5 W=0.9 AD=0.9675 PD=3.05 AS=0.495 PS=2.9
M1475 722 110 GND GND MN L=0.5 W=0.9 AD=0.9675 PD=3.05 AS=0.495 PS=2.9
M1476 723 111 GND GND MN L=0.5 W=0.9 AD=0.9675 PD=3.05 AS=0.495 PS=2.9
M1477 724 112 GND GND MN L=0.5 W=0.9 AD=0.9675 PD=3.05 AS=0.495 PS=2.9
M1478 725 113 GND GND MN L=0.5 W=0.9 AD=0.9675 PD=3.05 AS=0.495 PS=2.9
M1479 726 114 GND GND MN L=0.5 W=0.9 AD=1.935 PD=6.1 AS=0.2475 PS=1.45
M1480 442 GND GND GND MN L=0.5 W=0.9 AD=1.935 PD=6.1 AS=0.5625 PS=2.15
M1481 443 150 GND GND MN L=0.5 W=0.9 AD=1.935 PD=6.1 AS=0.5625 PS=2.15
M1482 444 151 GND GND MN L=0.5 W=0.9 AD=1.935 PD=6.1 AS=0.5625 PS=2.15
M1483 445 152 GND GND MN L=0.5 W=0.9 AD=1.935 PD=6.1 AS=0.5625 PS=2.15
M1484 446 153 GND GND MN L=0.5 W=0.9 AD=1.935 PD=6.1 AS=0.5625 PS=2.15
M1485 447 154 GND GND MN L=0.5 W=0.9 AD=1.935 PD=6.1 AS=0.5625 PS=2.15
M1486 448 155 GND GND MN L=0.5 W=0.9 AD=0.9675 PD=3.05 AS=1.125 PS=4.3
M1487 449 156 GND GND MN L=0.5 W=0.9 AD=1.935 PD=6.1 AS=0.5625 PS=2.15
M1488 GND 166 442 GND MN L=0.5 W=0.9 AD=0.5625 PD=2.15 AS=2.565 PS=7.5
M1489 GND 167 443 GND MN L=0.5 W=0.9 AD=0.5625 PD=2.15 AS=2.565 PS=7.5
M1490 GND 168 444 GND MN L=0.5 W=0.9 AD=0.5625 PD=2.15 AS=2.565 PS=7.5
M1491 GND 169 445 GND MN L=0.5 W=0.9 AD=0.5625 PD=2.15 AS=2.565 PS=7.5
M1492 GND 170 446 GND MN L=0.5 W=0.9 AD=0.5625 PD=2.15 AS=2.565 PS=7.5
M1493 GND 171 447 GND MN L=0.5 W=0.9 AD=0.5625 PD=2.15 AS=2.565 PS=7.5
M1494 GND 172 448 GND MN L=0.5 W=0.9 AD=0.5625 PD=2.15 AS=2.565 PS=7.5
M1495 GND 173 449 GND MN L=0.5 W=0.9 AD=0.5625 PD=2.15 AS=2.565 PS=7.5
M1496 166 159 719 GND MN L=0.5 W=0.9 AD=0.2475 PD=1.45 AS=1.125 PS=4.3
M1497 167 160 720 GND MN L=0.5 W=0.9 AD=0.2475 PD=1.45 AS=1.125 PS=4.3
M1498 168 161 721 GND MN L=0.5 W=0.9 AD=0.2475 PD=1.45 AS=1.125 PS=4.3
M1499 169 162 722 GND MN L=0.5 W=0.9 AD=0.2475 PD=1.45 AS=1.125 PS=4.3
M1500 170 163 723 GND MN L=0.5 W=0.9 AD=0.2475 PD=1.45 AS=1.125 PS=4.3
M1501 171 164 724 GND MN L=0.5 W=0.9 AD=0.2475 PD=1.45 AS=1.125 PS=4.3
M1502 172 165 725 GND MN L=0.5 W=0.9 AD=0.2475 PD=1.45 AS=1.125 PS=4.3
M1503 173 158 726 GND MN L=0.5 W=0.9 AD=0.2475 PD=1.45 AS=1.125 PS=4.3
M1504 GND 466 149 GND MN L=0.5 W=0.9 AD=0.4725 PD=1.95 AS=1.935 PS=6.1
M1505 GND 450 166 GND MN L=0.5 W=0.9 AD=1.125 PD=4.3 AS=1.2825 PS=3.75
M1506 GND 451 167 GND MN L=0.5 W=0.9 AD=1.125 PD=4.3 AS=1.2825 PS=3.75
M1507 GND 452 168 GND MN L=0.5 W=0.9 AD=1.125 PD=4.3 AS=1.2825 PS=3.75
M1508 GND 453 169 GND MN L=0.5 W=0.9 AD=1.125 PD=4.3 AS=1.2825 PS=3.75
M1509 GND 454 170 GND MN L=0.5 W=0.9 AD=1.125 PD=4.3 AS=1.2825 PS=3.75
M1510 GND 455 171 GND MN L=0.5 W=0.9 AD=1.125 PD=4.3 AS=1.2825 PS=3.75
M1511 GND 456 172 GND MN L=0.5 W=0.9 AD=1.125 PD=4.3 AS=1.2825 PS=3.75
M1512 GND 457 173 GND MN L=0.5 W=0.9 AD=0.5625 PD=2.15 AS=2.565 PS=7.5
M1513 727 27 GND GND MN L=0.5 W=0.9 AD=0.9675 PD=3.05 AS=0.495 PS=2.9
M1514 466 174 727 GND MN L=0.5 W=0.9 AD=0.2475 PD=1.45 AS=0.99 PS=4
M1515 467 166 GND GND MN L=0.5 W=0.9 AD=0.99 PD=4 AS=0.945 PS=3.9
M1516 468 167 GND GND MN L=0.5 W=0.9 AD=0.99 PD=4 AS=0.945 PS=3.9
M1517 469 168 GND GND MN L=0.5 W=0.9 AD=0.99 PD=4 AS=0.945 PS=3.9
M1518 470 169 GND GND MN L=0.5 W=0.9 AD=0.99 PD=4 AS=0.945 PS=3.9
M1519 471 170 GND GND MN L=0.5 W=0.9 AD=0.99 PD=4 AS=0.945 PS=3.9
M1520 472 171 GND GND MN L=0.5 W=0.9 AD=0.99 PD=4 AS=0.4725 PS=1.95
M1521 473 172 GND GND MN L=0.5 W=0.9 AD=0.99 PD=4 AS=0.4725 PS=1.95
M1522 474 173 GND GND MN L=0.5 W=0.9 AD=0.99 PD=4 AS=0.4725 PS=1.95
M1523 GND 475 159 GND MN L=0.5 W=0.9 AD=0.4725 PD=1.95 AS=1.935 PS=6.1
M1524 GND 476 160 GND MN L=0.5 W=0.9 AD=0.4725 PD=1.95 AS=1.935 PS=6.1
M1525 GND 477 161 GND MN L=0.5 W=0.9 AD=0.4725 PD=1.95 AS=1.935 PS=6.1
M1526 GND 478 162 GND MN L=0.5 W=0.9 AD=0.4725 PD=1.95 AS=1.935 PS=6.1
M1527 GND 479 163 GND MN L=0.5 W=0.9 AD=0.4725 PD=1.95 AS=1.935 PS=6.1
M1528 GND 480 164 GND MN L=0.5 W=0.9 AD=0.945 PD=3.9 AS=0.9675 PS=3.05
M1529 GND 481 165 GND MN L=0.5 W=0.9 AD=0.945 PD=3.9 AS=0.9675 PS=3.05
M1530 728 28 GND GND MN L=0.5 W=0.9 AD=0.9675 PD=3.05 AS=0.495 PS=2.9
M1531 729 29 GND GND MN L=0.5 W=0.9 AD=0.9675 PD=3.05 AS=0.495 PS=2.9
M1532 730 30 GND GND MN L=0.5 W=0.9 AD=0.9675 PD=3.05 AS=0.495 PS=2.9
M1533 731 31 GND GND MN L=0.5 W=0.9 AD=0.9675 PD=3.05 AS=0.495 PS=2.9
M1534 732 32 GND GND MN L=0.5 W=0.9 AD=0.9675 PD=3.05 AS=0.495 PS=2.9
M1535 733 33 GND GND MN L=0.5 W=0.9 AD=0.9675 PD=3.05 AS=0.495 PS=2.9
M1536 734 34 GND GND MN L=0.5 W=0.9 AD=0.9675 PD=3.05 AS=0.495 PS=2.9
M1537 150 467 159 GND MN L=0.5 W=0.9 AD=0.99 PD=4 AS=0.5625 PS=2.15
M1538 151 468 160 GND MN L=0.5 W=0.9 AD=0.99 PD=4 AS=0.5625 PS=2.15
M1539 152 469 161 GND MN L=0.5 W=0.9 AD=0.99 PD=4 AS=0.5625 PS=2.15
M1540 153 470 162 GND MN L=0.5 W=0.9 AD=0.99 PD=4 AS=0.5625 PS=2.15
M1541 154 471 163 GND MN L=0.5 W=0.9 AD=0.99 PD=4 AS=0.5625 PS=2.15
M1542 155 472 164 GND MN L=0.5 W=0.9 AD=0.99 PD=4 AS=0.5625 PS=2.15
M1543 156 473 165 GND MN L=0.5 W=0.9 AD=0.99 PD=4 AS=0.5625 PS=2.15
M1544 130 474 158 GND MN L=0.5 W=0.9 AD=0.495 PD=2 AS=1.125 PS=4.3
M1545 174 482 GND GND MN L=0.5 W=0.9 AD=0.9 PD=2.9 AS=1.125 PS=4.3
M1546 GND 166 150 GND MN L=0.5 W=0.9 AD=0.5625 PD=2.15 AS=0.945 PS=3.9
M1547 150 167 151 GND MN L=0.5 W=0.9 AD=0.5625 PD=2.15 AS=0.945 PS=3.9
M1548 151 168 152 GND MN L=0.5 W=0.9 AD=0.5625 PD=2.15 AS=0.945 PS=3.9
M1549 152 169 153 GND MN L=0.5 W=0.9 AD=0.5625 PD=2.15 AS=0.945 PS=3.9
M1550 153 170 154 GND MN L=0.5 W=0.9 AD=0.5625 PD=2.15 AS=0.945 PS=3.9
M1551 154 171 155 GND MN L=0.5 W=0.9 AD=0.5625 PD=2.15 AS=0.945 PS=3.9
M1552 155 172 156 GND MN L=0.5 W=0.9 AD=0.5625 PD=2.15 AS=0.945 PS=3.9
M1553 156 173 130 GND MN L=0.5 W=0.9 AD=0.5625 PD=2.15 AS=0.945 PS=3.9
M1554 475 174 728 GND MN L=0.5 W=0.9 AD=0.2475 PD=1.45 AS=0.99 PS=4
M1555 476 174 729 GND MN L=0.5 W=0.9 AD=0.2475 PD=1.45 AS=0.99 PS=4
M1556 477 174 730 GND MN L=0.5 W=0.9 AD=0.2475 PD=1.45 AS=0.99 PS=4
M1557 478 174 731 GND MN L=0.5 W=0.9 AD=0.2475 PD=1.45 AS=0.99 PS=4
M1558 479 174 732 GND MN L=0.5 W=0.9 AD=0.2475 PD=1.45 AS=0.99 PS=4
M1559 480 174 733 GND MN L=0.5 W=0.9 AD=0.2475 PD=1.45 AS=0.99 PS=4
M1560 481 174 734 GND MN L=0.5 W=0.9 AD=0.2475 PD=1.45 AS=0.99 PS=4
M1561 GND 482 174 GND MN L=0.5 W=0.9 AD=0.5625 PD=2.15 AS=1.935 PS=6.1
M1562 482 A<3> GND GND MN L=0.5 W=0.9 AD=0.9675 PD=3.05 AS=0.99 PS=4
M1563 176 491 GND GND MN L=0.5 W=0.9 AD=2.565 PD=7.5 AS=0.5625 PS=2.15
M1564 177 492 GND GND MN L=0.5 W=0.9 AD=2.565 PD=7.5 AS=0.5625 PS=2.15
M1565 178 493 GND GND MN L=0.5 W=0.9 AD=2.565 PD=7.5 AS=0.5625 PS=2.15
M1566 179 494 GND GND MN L=0.5 W=0.9 AD=2.565 PD=7.5 AS=0.5625 PS=2.15
M1567 180 495 GND GND MN L=0.5 W=0.9 AD=2.565 PD=7.5 AS=0.5625 PS=2.15
M1568 181 496 GND GND MN L=0.5 W=0.9 AD=2.565 PD=7.5 AS=0.5625 PS=2.15
M1569 182 497 GND GND MN L=0.5 W=0.9 AD=2.565 PD=7.5 AS=0.5625 PS=2.15
M1570 P<10> 498 GND GND MN L=0.5 W=0.9 AD=2.565 PD=7.5 AS=0.5625 PS=2.15
M1571 735 GND 176 GND MN L=0.5 W=0.9 AD=0.5625 PD=2.15 AS=0.495 PS=2.9
M1572 736 185 177 GND MN L=0.5 W=0.9 AD=0.5625 PD=2.15 AS=0.495 PS=2.9
M1573 737 186 178 GND MN L=0.5 W=0.9 AD=0.5625 PD=2.15 AS=0.495 PS=2.9
M1574 738 187 179 GND MN L=0.5 W=0.9 AD=0.5625 PD=2.15 AS=0.495 PS=2.9
M1575 739 188 180 GND MN L=0.5 W=0.9 AD=0.5625 PD=2.15 AS=0.495 PS=2.9
M1576 740 189 181 GND MN L=0.5 W=0.9 AD=0.5625 PD=2.15 AS=0.495 PS=2.9
M1577 741 190 182 GND MN L=0.5 W=0.9 AD=0.5625 PD=2.15 AS=0.495 PS=2.9
M1578 742 191 P<10> GND MN L=0.5 W=0.9 AD=0.5625 PD=2.15 AS=0.495 PS=2.9
M1579 499 149 GND GND MN L=0.5 W=0.9 AD=2.565 PD=7.5 AS=0.5625 PS=2.15
M1580 500 142 GND GND MN L=0.5 W=0.9 AD=2.565 PD=7.5 AS=0.5625 PS=2.15
M1581 501 143 GND GND MN L=0.5 W=0.9 AD=2.565 PD=7.5 AS=0.5625 PS=2.15
M1582 502 144 GND GND MN L=0.5 W=0.9 AD=2.565 PD=7.5 AS=0.5625 PS=2.15
M1583 503 145 GND GND MN L=0.5 W=0.9 AD=2.565 PD=7.5 AS=0.5625 PS=2.15
M1584 504 146 GND GND MN L=0.5 W=0.9 AD=2.565 PD=7.5 AS=0.5625 PS=2.15
M1585 505 147 GND GND MN L=0.5 W=0.9 AD=2.565 PD=7.5 AS=0.5625 PS=2.15
M1586 506 148 GND GND MN L=0.5 W=0.9 AD=2.565 PD=7.5 AS=0.5625 PS=2.15
M1587 GND 200 735 GND MN L=0.5 W=0.9 AD=0.495 PD=2.9 AS=0.9675 PS=3.05
M1588 GND 201 736 GND MN L=0.5 W=0.9 AD=0.495 PD=2.9 AS=0.9675 PS=3.05
M1589 GND 202 737 GND MN L=0.5 W=0.9 AD=0.495 PD=2.9 AS=0.9675 PS=3.05
M1590 GND 203 738 GND MN L=0.5 W=0.9 AD=0.495 PD=2.9 AS=0.9675 PS=3.05
M1591 GND 204 739 GND MN L=0.5 W=0.9 AD=0.495 PD=2.9 AS=0.9675 PS=3.05
M1592 GND 205 740 GND MN L=0.5 W=0.9 AD=0.495 PD=2.9 AS=0.9675 PS=3.05
M1593 GND 206 741 GND MN L=0.5 W=0.9 AD=0.495 PD=2.9 AS=0.9675 PS=3.05
M1594 GND 207 742 GND MN L=0.5 W=0.9 AD=0.495 PD=2.9 AS=0.9675 PS=3.05
M1595 GND 192 499 GND MN L=0.5 W=0.9 AD=0.5625 PD=2.15 AS=1.935 PS=6.1
M1596 GND 193 500 GND MN L=0.5 W=0.9 AD=0.5625 PD=2.15 AS=1.935 PS=6.1
M1597 GND 194 501 GND MN L=0.5 W=0.9 AD=0.5625 PD=2.15 AS=1.935 PS=6.1
M1598 GND 195 502 GND MN L=0.5 W=0.9 AD=0.5625 PD=2.15 AS=1.935 PS=6.1
M1599 GND 196 503 GND MN L=0.5 W=0.9 AD=0.5625 PD=2.15 AS=1.935 PS=6.1
M1600 GND 197 504 GND MN L=0.5 W=0.9 AD=0.5625 PD=2.15 AS=1.935 PS=6.1
M1601 GND 198 505 GND MN L=0.5 W=0.9 AD=0.5625 PD=2.15 AS=1.935 PS=6.1
M1602 GND 199 506 GND MN L=0.5 W=0.9 AD=0.5625 PD=2.15 AS=1.935 PS=6.1
M1603 743 149 GND GND MN L=0.5 W=0.9 AD=0.9675 PD=3.05 AS=0.495 PS=2.9
M1604 744 142 GND GND MN L=0.5 W=0.9 AD=0.9675 PD=3.05 AS=0.495 PS=2.9
M1605 745 143 GND GND MN L=0.5 W=0.9 AD=0.9675 PD=3.05 AS=0.495 PS=2.9
M1606 746 144 GND GND MN L=0.5 W=0.9 AD=0.9675 PD=3.05 AS=0.495 PS=2.9
M1607 747 145 GND GND MN L=0.5 W=0.9 AD=0.9675 PD=3.05 AS=0.495 PS=2.9
M1608 748 146 GND GND MN L=0.5 W=0.9 AD=0.9675 PD=3.05 AS=0.495 PS=2.9
M1609 749 147 GND GND MN L=0.5 W=0.9 AD=1.935 PD=6.1 AS=0.2475 PS=1.45
M1610 750 148 GND GND MN L=0.5 W=0.9 AD=0.9675 PD=3.05 AS=0.495 PS=2.9
M1611 491 GND GND GND MN L=0.5 W=0.9 AD=0.9675 PD=3.05 AS=1.125 PS=4.3
M1612 492 185 GND GND MN L=0.5 W=0.9 AD=0.9675 PD=3.05 AS=1.125 PS=4.3
M1613 493 186 GND GND MN L=0.5 W=0.9 AD=0.9675 PD=3.05 AS=1.125 PS=4.3
M1614 494 187 GND GND MN L=0.5 W=0.9 AD=0.9675 PD=3.05 AS=1.125 PS=4.3
M1615 495 188 GND GND MN L=0.5 W=0.9 AD=0.9675 PD=3.05 AS=1.125 PS=4.3
M1616 496 189 GND GND MN L=0.5 W=0.9 AD=0.9675 PD=3.05 AS=1.125 PS=4.3
M1617 497 190 GND GND MN L=0.5 W=0.9 AD=0.9675 PD=3.05 AS=1.125 PS=4.3
M1618 498 191 GND GND MN L=0.5 W=0.9 AD=0.9675 PD=3.05 AS=1.125 PS=4.3
M1619 GND 515 183 GND MN L=0.5 W=0.9 AD=0.945 PD=3.9 AS=0.9675 PS=3.05
M1620 GND 200 491 GND MN L=0.5 W=0.9 AD=0.5625 PD=2.15 AS=2.565 PS=7.5
M1621 GND 201 492 GND MN L=0.5 W=0.9 AD=0.5625 PD=2.15 AS=2.565 PS=7.5
M1622 GND 202 493 GND MN L=0.5 W=0.9 AD=0.5625 PD=2.15 AS=2.565 PS=7.5
M1623 GND 203 494 GND MN L=0.5 W=0.9 AD=0.5625 PD=2.15 AS=2.565 PS=7.5
M1624 GND 204 495 GND MN L=0.5 W=0.9 AD=0.5625 PD=2.15 AS=2.565 PS=7.5
M1625 GND 205 496 GND MN L=0.5 W=0.9 AD=0.5625 PD=2.15 AS=2.565 PS=7.5
M1626 GND 206 497 GND MN L=0.5 W=0.9 AD=0.5625 PD=2.15 AS=2.565 PS=7.5
M1627 GND 207 498 GND MN L=0.5 W=0.9 AD=1.125 PD=4.3 AS=1.2825 PS=3.75
M1628 200 192 743 GND MN L=0.5 W=0.9 AD=0.495 PD=2.9 AS=0.5625 PS=2.15
M1629 201 193 744 GND MN L=0.5 W=0.9 AD=0.495 PD=2.9 AS=0.5625 PS=2.15
M1630 202 194 745 GND MN L=0.5 W=0.9 AD=0.495 PD=2.9 AS=0.5625 PS=2.15
M1631 203 195 746 GND MN L=0.5 W=0.9 AD=0.495 PD=2.9 AS=0.5625 PS=2.15
M1632 204 196 747 GND MN L=0.5 W=0.9 AD=0.495 PD=2.9 AS=0.5625 PS=2.15
M1633 205 197 748 GND MN L=0.5 W=0.9 AD=0.495 PD=2.9 AS=0.5625 PS=2.15
M1634 206 198 749 GND MN L=0.5 W=0.9 AD=0.2475 PD=1.45 AS=1.125 PS=4.3
M1635 207 199 750 GND MN L=0.5 W=0.9 AD=0.495 PD=2.9 AS=0.5625 PS=2.15
M1636 751 27 GND GND MN L=0.5 W=0.9 AD=1.935 PD=6.1 AS=0.2475 PS=1.45
M1637 GND 499 200 GND MN L=0.5 W=0.9 AD=0.5625 PD=2.15 AS=2.565 PS=7.5
M1638 GND 500 201 GND MN L=0.5 W=0.9 AD=0.5625 PD=2.15 AS=2.565 PS=7.5
M1639 GND 501 202 GND MN L=0.5 W=0.9 AD=0.5625 PD=2.15 AS=2.565 PS=7.5
M1640 GND 502 203 GND MN L=0.5 W=0.9 AD=0.5625 PD=2.15 AS=2.565 PS=7.5
M1641 GND 503 204 GND MN L=0.5 W=0.9 AD=0.5625 PD=2.15 AS=2.565 PS=7.5
M1642 GND 504 205 GND MN L=0.5 W=0.9 AD=0.5625 PD=2.15 AS=2.565 PS=7.5
M1643 GND 505 206 GND MN L=0.5 W=0.9 AD=0.5625 PD=2.15 AS=2.565 PS=7.5
M1644 GND 506 207 GND MN L=0.5 W=0.9 AD=0.5625 PD=2.15 AS=2.565 PS=7.5
M1645 515 208 751 GND MN L=0.5 W=0.9 AD=0.2475 PD=1.45 AS=0.99 PS=4
M1646 516 200 GND GND MN L=0.5 W=0.9 AD=0.99 PD=4 AS=0.4725 PS=1.95
M1647 517 201 GND GND MN L=0.5 W=0.9 AD=0.99 PD=4 AS=0.4725 PS=1.95
M1648 518 202 GND GND MN L=0.5 W=0.9 AD=0.99 PD=4 AS=0.4725 PS=1.95
M1649 519 203 GND GND MN L=0.5 W=0.9 AD=0.99 PD=4 AS=0.4725 PS=1.95
M1650 520 204 GND GND MN L=0.5 W=0.9 AD=0.99 PD=4 AS=0.4725 PS=1.95
M1651 521 205 GND GND MN L=0.5 W=0.9 AD=0.495 PD=2 AS=0.945 PS=3.9
M1652 522 206 GND GND MN L=0.5 W=0.9 AD=0.495 PD=2 AS=0.945 PS=3.9
M1653 523 207 GND GND MN L=0.5 W=0.9 AD=0.495 PD=2 AS=0.945 PS=3.9
M1654 GND 524 192 GND MN L=0.5 W=0.9 AD=0.945 PD=3.9 AS=0.9675 PS=3.05
M1655 GND 525 193 GND MN L=0.5 W=0.9 AD=0.945 PD=3.9 AS=0.9675 PS=3.05
M1656 GND 526 194 GND MN L=0.5 W=0.9 AD=0.945 PD=3.9 AS=0.9675 PS=3.05
M1657 GND 527 195 GND MN L=0.5 W=0.9 AD=0.945 PD=3.9 AS=0.9675 PS=3.05
M1658 GND 528 196 GND MN L=0.5 W=0.9 AD=0.945 PD=3.9 AS=0.9675 PS=3.05
M1659 GND 529 197 GND MN L=0.5 W=0.9 AD=0.945 PD=3.9 AS=0.9675 PS=3.05
M1660 GND 530 198 GND MN L=0.5 W=0.9 AD=0.945 PD=3.9 AS=0.9675 PS=3.05
M1661 208 531 GND GND MN L=0.5 W=0.9 AD=1.8 PD=5.8 AS=0.5625 PS=2.15
M1662 752 28 GND GND MN L=0.5 W=0.9 AD=0.9675 PD=3.05 AS=0.495 PS=2.9
M1663 753 29 GND GND MN L=0.5 W=0.9 AD=0.9675 PD=3.05 AS=0.495 PS=2.9
M1664 754 30 GND GND MN L=0.5 W=0.9 AD=0.9675 PD=3.05 AS=0.495 PS=2.9
M1665 755 31 GND GND MN L=0.5 W=0.9 AD=0.9675 PD=3.05 AS=0.495 PS=2.9
M1666 756 32 GND GND MN L=0.5 W=0.9 AD=0.9675 PD=3.05 AS=0.495 PS=2.9
M1667 757 33 GND GND MN L=0.5 W=0.9 AD=0.9675 PD=3.05 AS=0.495 PS=2.9
M1668 758 34 GND GND MN L=0.5 W=0.9 AD=0.9675 PD=3.05 AS=0.495 PS=2.9
M1669 185 516 192 GND MN L=0.5 W=0.9 AD=0.99 PD=4 AS=0.5625 PS=2.15
M1670 186 517 193 GND MN L=0.5 W=0.9 AD=0.99 PD=4 AS=0.5625 PS=2.15
M1671 187 518 194 GND MN L=0.5 W=0.9 AD=0.99 PD=4 AS=0.5625 PS=2.15
M1672 188 519 195 GND MN L=0.5 W=0.9 AD=0.99 PD=4 AS=0.5625 PS=2.15
M1673 189 520 196 GND MN L=0.5 W=0.9 AD=0.99 PD=4 AS=0.5625 PS=2.15
M1674 190 521 197 GND MN L=0.5 W=0.9 AD=0.99 PD=4 AS=0.5625 PS=2.15
M1675 191 522 198 GND MN L=0.5 W=0.9 AD=0.495 PD=2 AS=1.125 PS=4.3
M1676 158 523 199 GND MN L=0.5 W=0.9 AD=0.495 PD=2 AS=1.125 PS=4.3
M1677 GND 531 208 GND MN L=0.5 W=0.9 AD=1.125 PD=4.3 AS=0.9675 PS=3.05
M1678 GND 200 185 GND MN L=0.5 W=0.9 AD=0.5625 PD=2.15 AS=0.945 PS=3.9
M1679 185 201 186 GND MN L=0.5 W=0.9 AD=0.5625 PD=2.15 AS=0.945 PS=3.9
M1680 186 202 187 GND MN L=0.5 W=0.9 AD=0.5625 PD=2.15 AS=0.945 PS=3.9
M1681 187 203 188 GND MN L=0.5 W=0.9 AD=0.5625 PD=2.15 AS=0.945 PS=3.9
M1682 188 204 189 GND MN L=0.5 W=0.9 AD=0.5625 PD=2.15 AS=0.945 PS=3.9
M1683 189 205 190 GND MN L=0.5 W=0.9 AD=0.5625 PD=2.15 AS=0.945 PS=3.9
M1684 190 206 191 GND MN L=0.5 W=0.9 AD=0.5625 PD=2.15 AS=0.945 PS=3.9
M1685 191 207 158 GND MN L=0.5 W=0.9 AD=0.5625 PD=2.15 AS=0.945 PS=3.9
M1686 524 208 752 GND MN L=0.5 W=0.9 AD=0.2475 PD=1.45 AS=0.99 PS=4
M1687 525 208 753 GND MN L=0.5 W=0.9 AD=0.2475 PD=1.45 AS=0.99 PS=4
M1688 526 208 754 GND MN L=0.5 W=0.9 AD=0.2475 PD=1.45 AS=0.99 PS=4
M1689 527 208 755 GND MN L=0.5 W=0.9 AD=0.2475 PD=1.45 AS=0.99 PS=4
M1690 528 208 756 GND MN L=0.5 W=0.9 AD=0.2475 PD=1.45 AS=0.99 PS=4
M1691 529 208 757 GND MN L=0.5 W=0.9 AD=0.2475 PD=1.45 AS=0.99 PS=4
M1692 530 208 758 GND MN L=0.5 W=0.9 AD=0.2475 PD=1.45 AS=0.99 PS=4
M1693 531 A<2> GND GND MN L=0.5 W=0.9 AD=0.9675 PD=3.05 AS=0.99 PS=4
M1694 210 540 GND GND MN L=0.5 W=0.9 AD=2.565 PD=7.5 AS=0.5625 PS=2.15
M1695 211 541 GND GND MN L=0.5 W=0.9 AD=2.565 PD=7.5 AS=0.5625 PS=2.15
M1696 212 542 GND GND MN L=0.5 W=0.9 AD=2.565 PD=7.5 AS=0.5625 PS=2.15
M1697 213 543 GND GND MN L=0.5 W=0.9 AD=2.565 PD=7.5 AS=0.5625 PS=2.15
M1698 214 544 GND GND MN L=0.5 W=0.9 AD=2.565 PD=7.5 AS=0.5625 PS=2.15
M1699 215 545 GND GND MN L=0.5 W=0.9 AD=2.565 PD=7.5 AS=0.5625 PS=2.15
M1700 216 546 GND GND MN L=0.5 W=0.9 AD=2.565 PD=7.5 AS=0.5625 PS=2.15
M1701 P<9> 547 GND GND MN L=0.5 W=0.9 AD=2.565 PD=7.5 AS=0.5625 PS=2.15
M1702 759 GND 210 GND MN L=0.5 W=0.9 AD=0.5625 PD=2.15 AS=0.495 PS=2.9
M1703 760 219 211 GND MN L=0.5 W=0.9 AD=0.5625 PD=2.15 AS=0.495 PS=2.9
M1704 761 220 212 GND MN L=0.5 W=0.9 AD=0.5625 PD=2.15 AS=0.495 PS=2.9
M1705 762 221 213 GND MN L=0.5 W=0.9 AD=0.5625 PD=2.15 AS=0.495 PS=2.9
M1706 763 222 214 GND MN L=0.5 W=0.9 AD=0.5625 PD=2.15 AS=0.495 PS=2.9
M1707 764 223 215 GND MN L=0.5 W=0.9 AD=0.5625 PD=2.15 AS=0.495 PS=2.9
M1708 765 224 216 GND MN L=0.5 W=0.9 AD=0.5625 PD=2.15 AS=0.495 PS=2.9
M1709 766 225 P<9> GND MN L=0.5 W=0.9 AD=0.5625 PD=2.15 AS=0.495 PS=2.9
M1710 548 183 GND GND MN L=0.5 W=0.9 AD=2.565 PD=7.5 AS=0.5625 PS=2.15
M1711 549 176 GND GND MN L=0.5 W=0.9 AD=2.565 PD=7.5 AS=0.5625 PS=2.15
M1712 550 177 GND GND MN L=0.5 W=0.9 AD=2.565 PD=7.5 AS=0.5625 PS=2.15
M1713 551 178 GND GND MN L=0.5 W=0.9 AD=2.565 PD=7.5 AS=0.5625 PS=2.15
M1714 552 179 GND GND MN L=0.5 W=0.9 AD=2.565 PD=7.5 AS=0.5625 PS=2.15
M1715 553 180 GND GND MN L=0.5 W=0.9 AD=2.565 PD=7.5 AS=0.5625 PS=2.15
M1716 554 181 GND GND MN L=0.5 W=0.9 AD=2.565 PD=7.5 AS=0.5625 PS=2.15
M1717 555 182 GND GND MN L=0.5 W=0.9 AD=2.565 PD=7.5 AS=0.5625 PS=2.15
M1718 GND 234 759 GND MN L=0.5 W=0.9 AD=0.2475 PD=1.45 AS=1.935 PS=6.1
M1719 GND 235 760 GND MN L=0.5 W=0.9 AD=0.2475 PD=1.45 AS=1.935 PS=6.1
M1720 GND 236 761 GND MN L=0.5 W=0.9 AD=0.2475 PD=1.45 AS=1.935 PS=6.1
M1721 GND 237 762 GND MN L=0.5 W=0.9 AD=0.2475 PD=1.45 AS=1.935 PS=6.1
M1722 GND 238 763 GND MN L=0.5 W=0.9 AD=0.2475 PD=1.45 AS=1.935 PS=6.1
M1723 GND 239 764 GND MN L=0.5 W=0.9 AD=0.2475 PD=1.45 AS=1.935 PS=6.1
M1724 GND 240 765 GND MN L=0.5 W=0.9 AD=0.2475 PD=1.45 AS=1.935 PS=6.1
M1725 GND 241 766 GND MN L=0.5 W=0.9 AD=0.495 PD=2.9 AS=0.9675 PS=3.05
M1726 GND 227 548 GND MN L=0.5 W=0.9 AD=1.125 PD=4.3 AS=0.9675 PS=3.05
M1727 GND 228 549 GND MN L=0.5 W=0.9 AD=0.5625 PD=2.15 AS=1.935 PS=6.1
M1728 GND 229 550 GND MN L=0.5 W=0.9 AD=0.5625 PD=2.15 AS=1.935 PS=6.1
M1729 GND 230 551 GND MN L=0.5 W=0.9 AD=0.5625 PD=2.15 AS=1.935 PS=6.1
M1730 GND 231 552 GND MN L=0.5 W=0.9 AD=0.5625 PD=2.15 AS=1.935 PS=6.1
M1731 GND 232 553 GND MN L=0.5 W=0.9 AD=0.5625 PD=2.15 AS=1.935 PS=6.1
M1732 GND 233 554 GND MN L=0.5 W=0.9 AD=0.5625 PD=2.15 AS=1.935 PS=6.1
M1733 GND 226 555 GND MN L=0.5 W=0.9 AD=0.5625 PD=2.15 AS=1.935 PS=6.1
M1734 GND 564 218 GND MN L=0.5 W=0.9 AD=0.945 PD=3.9 AS=0.9675 PS=3.05
M1735 767 183 GND GND MN L=0.5 W=0.9 AD=0.9675 PD=3.05 AS=0.495 PS=2.9
M1736 768 176 GND GND MN L=0.5 W=0.9 AD=0.9675 PD=3.05 AS=0.495 PS=2.9
M1737 769 177 GND GND MN L=0.5 W=0.9 AD=0.9675 PD=3.05 AS=0.495 PS=2.9
M1738 770 178 GND GND MN L=0.5 W=0.9 AD=0.9675 PD=3.05 AS=0.495 PS=2.9
M1739 771 179 GND GND MN L=0.5 W=0.9 AD=0.9675 PD=3.05 AS=0.495 PS=2.9
M1740 772 180 GND GND MN L=0.5 W=0.9 AD=0.9675 PD=3.05 AS=0.495 PS=2.9
M1741 773 181 GND GND MN L=0.5 W=0.9 AD=0.9675 PD=3.05 AS=0.495 PS=2.9
M1742 774 182 GND GND MN L=0.5 W=0.9 AD=0.9675 PD=3.05 AS=0.495 PS=2.9
M1743 775 27 GND GND MN L=0.5 W=0.9 AD=0.9675 PD=3.05 AS=0.495 PS=2.9
M1744 540 GND GND GND MN L=0.5 W=0.9 AD=0.9675 PD=3.05 AS=1.125 PS=4.3
M1745 541 219 GND GND MN L=0.5 W=0.9 AD=0.9675 PD=3.05 AS=1.125 PS=4.3
M1746 542 220 GND GND MN L=0.5 W=0.9 AD=0.9675 PD=3.05 AS=1.125 PS=4.3
M1747 543 221 GND GND MN L=0.5 W=0.9 AD=0.9675 PD=3.05 AS=1.125 PS=4.3
M1748 544 222 GND GND MN L=0.5 W=0.9 AD=0.9675 PD=3.05 AS=1.125 PS=4.3
M1749 545 223 GND GND MN L=0.5 W=0.9 AD=0.9675 PD=3.05 AS=1.125 PS=4.3
M1750 546 224 GND GND MN L=0.5 W=0.9 AD=0.9675 PD=3.05 AS=1.125 PS=4.3
M1751 547 225 GND GND MN L=0.5 W=0.9 AD=0.9675 PD=3.05 AS=1.125 PS=4.3
M1752 564 242 775 GND MN L=0.5 W=0.9 AD=0.2475 PD=1.45 AS=0.99 PS=4
M1753 GND 234 540 GND MN L=0.5 W=0.9 AD=0.5625 PD=2.15 AS=2.565 PS=7.5
M1754 GND 235 541 GND MN L=0.5 W=0.9 AD=0.5625 PD=2.15 AS=2.565 PS=7.5
M1755 GND 236 542 GND MN L=0.5 W=0.9 AD=0.5625 PD=2.15 AS=2.565 PS=7.5
M1756 GND 237 543 GND MN L=0.5 W=0.9 AD=0.5625 PD=2.15 AS=2.565 PS=7.5
M1757 GND 238 544 GND MN L=0.5 W=0.9 AD=0.5625 PD=2.15 AS=2.565 PS=7.5
M1758 GND 239 545 GND MN L=0.5 W=0.9 AD=0.5625 PD=2.15 AS=2.565 PS=7.5
M1759 GND 240 546 GND MN L=0.5 W=0.9 AD=0.5625 PD=2.15 AS=2.565 PS=7.5
M1760 GND 241 547 GND MN L=0.5 W=0.9 AD=0.5625 PD=2.15 AS=2.565 PS=7.5
M1761 234 227 767 GND MN L=0.5 W=0.9 AD=0.2475 PD=1.45 AS=1.125 PS=4.3
M1762 235 228 768 GND MN L=0.5 W=0.9 AD=0.2475 PD=1.45 AS=1.125 PS=4.3
M1763 236 229 769 GND MN L=0.5 W=0.9 AD=0.2475 PD=1.45 AS=1.125 PS=4.3
M1764 237 230 770 GND MN L=0.5 W=0.9 AD=0.2475 PD=1.45 AS=1.125 PS=4.3
M1765 238 231 771 GND MN L=0.5 W=0.9 AD=0.2475 PD=1.45 AS=1.125 PS=4.3
M1766 239 232 772 GND MN L=0.5 W=0.9 AD=0.2475 PD=1.45 AS=1.125 PS=4.3
M1767 240 233 773 GND MN L=0.5 W=0.9 AD=0.2475 PD=1.45 AS=1.125 PS=4.3
M1768 241 226 774 GND MN L=0.5 W=0.9 AD=0.2475 PD=1.45 AS=1.125 PS=4.3
M1769 GND 548 234 GND MN L=0.5 W=0.9 AD=0.5625 PD=2.15 AS=2.565 PS=7.5
M1770 GND 549 235 GND MN L=0.5 W=0.9 AD=0.5625 PD=2.15 AS=2.565 PS=7.5
M1771 GND 550 236 GND MN L=0.5 W=0.9 AD=0.5625 PD=2.15 AS=2.565 PS=7.5
M1772 GND 551 237 GND MN L=0.5 W=0.9 AD=0.5625 PD=2.15 AS=2.565 PS=7.5
M1773 GND 552 238 GND MN L=0.5 W=0.9 AD=0.5625 PD=2.15 AS=2.565 PS=7.5
M1774 GND 553 239 GND MN L=0.5 W=0.9 AD=1.125 PD=4.3 AS=1.2825 PS=3.75
M1775 GND 554 240 GND MN L=0.5 W=0.9 AD=1.125 PD=4.3 AS=1.2825 PS=3.75
M1776 GND 555 241 GND MN L=0.5 W=0.9 AD=1.125 PD=4.3 AS=1.2825 PS=3.75
M1777 565 234 GND GND MN L=0.5 W=0.9 AD=0.495 PD=2 AS=0.945 PS=3.9
M1778 566 235 GND GND MN L=0.5 W=0.9 AD=0.495 PD=2 AS=0.945 PS=3.9
M1779 567 236 GND GND MN L=0.5 W=0.9 AD=0.495 PD=2 AS=0.945 PS=3.9
M1780 568 237 GND GND MN L=0.5 W=0.9 AD=0.495 PD=2 AS=0.945 PS=3.9
M1781 569 238 GND GND MN L=0.5 W=0.9 AD=0.495 PD=2 AS=0.945 PS=3.9
M1782 570 239 GND GND MN L=0.5 W=0.9 AD=0.495 PD=2 AS=0.945 PS=3.9
M1783 571 240 GND GND MN L=0.5 W=0.9 AD=0.495 PD=2 AS=0.945 PS=3.9
M1784 572 241 GND GND MN L=0.5 W=0.9 AD=0.495 PD=2 AS=0.945 PS=3.9
M1785 242 580 GND GND MN L=0.5 W=0.9 AD=0.9 PD=2.9 AS=1.125 PS=4.3
M1786 GND 573 227 GND MN L=0.5 W=0.9 AD=0.945 PD=3.9 AS=0.9675 PS=3.05
M1787 GND 574 228 GND MN L=0.5 W=0.9 AD=0.945 PD=3.9 AS=0.9675 PS=3.05
M1788 GND 575 229 GND MN L=0.5 W=0.9 AD=0.945 PD=3.9 AS=0.9675 PS=3.05
M1789 GND 576 230 GND MN L=0.5 W=0.9 AD=0.945 PD=3.9 AS=0.9675 PS=3.05
M1790 GND 577 231 GND MN L=0.5 W=0.9 AD=0.945 PD=3.9 AS=0.9675 PS=3.05
M1791 GND 578 232 GND MN L=0.5 W=0.9 AD=0.4725 PD=1.95 AS=1.935 PS=6.1
M1792 GND 579 233 GND MN L=0.5 W=0.9 AD=0.4725 PD=1.95 AS=1.935 PS=6.1
M1793 GND 580 242 GND MN L=0.5 W=0.9 AD=0.5625 PD=2.15 AS=1.935 PS=6.1
M1794 776 28 GND GND MN L=0.5 W=0.9 AD=0.9675 PD=3.05 AS=0.495 PS=2.9
M1795 777 29 GND GND MN L=0.5 W=0.9 AD=0.9675 PD=3.05 AS=0.495 PS=2.9
M1796 778 30 GND GND MN L=0.5 W=0.9 AD=0.9675 PD=3.05 AS=0.495 PS=2.9
M1797 779 31 GND GND MN L=0.5 W=0.9 AD=0.9675 PD=3.05 AS=0.495 PS=2.9
M1798 780 32 GND GND MN L=0.5 W=0.9 AD=0.9675 PD=3.05 AS=0.495 PS=2.9
M1799 781 33 GND GND MN L=0.5 W=0.9 AD=0.9675 PD=3.05 AS=0.495 PS=2.9
M1800 782 34 GND GND MN L=0.5 W=0.9 AD=1.935 PD=6.1 AS=0.2475 PS=1.45
M1801 219 565 227 GND MN L=0.5 W=0.9 AD=0.495 PD=2 AS=1.125 PS=4.3
M1802 220 566 228 GND MN L=0.5 W=0.9 AD=0.495 PD=2 AS=1.125 PS=4.3
M1803 221 567 229 GND MN L=0.5 W=0.9 AD=0.495 PD=2 AS=1.125 PS=4.3
M1804 222 568 230 GND MN L=0.5 W=0.9 AD=0.495 PD=2 AS=1.125 PS=4.3
M1805 223 569 231 GND MN L=0.5 W=0.9 AD=0.495 PD=2 AS=1.125 PS=4.3
M1806 224 570 232 GND MN L=0.5 W=0.9 AD=0.99 PD=4 AS=0.5625 PS=2.15
M1807 225 571 233 GND MN L=0.5 W=0.9 AD=0.99 PD=4 AS=0.5625 PS=2.15
M1808 199 572 226 GND MN L=0.5 W=0.9 AD=0.99 PD=4 AS=0.5625 PS=2.15
M1809 580 A<1> GND GND MN L=0.5 W=0.9 AD=0.9675 PD=3.05 AS=0.99 PS=4
M1810 GND 234 219 GND MN L=0.5 W=0.9 AD=0.5625 PD=2.15 AS=0.945 PS=3.9
M1811 219 235 220 GND MN L=0.5 W=0.9 AD=0.5625 PD=2.15 AS=0.945 PS=3.9
M1812 220 236 221 GND MN L=0.5 W=0.9 AD=0.5625 PD=2.15 AS=0.945 PS=3.9
M1813 221 237 222 GND MN L=0.5 W=0.9 AD=0.5625 PD=2.15 AS=0.945 PS=3.9
M1814 222 238 223 GND MN L=0.5 W=0.9 AD=0.5625 PD=2.15 AS=0.945 PS=3.9
M1815 223 239 224 GND MN L=0.5 W=0.9 AD=0.5625 PD=2.15 AS=0.945 PS=3.9
M1816 224 240 225 GND MN L=0.5 W=0.9 AD=0.5625 PD=2.15 AS=0.945 PS=3.9
M1817 225 241 199 GND MN L=0.5 W=0.9 AD=0.5625 PD=2.15 AS=0.945 PS=3.9
M1818 573 242 776 GND MN L=0.5 W=0.9 AD=0.495 PD=2.9 AS=0.495 PS=2
M1819 574 242 777 GND MN L=0.5 W=0.9 AD=0.495 PD=2.9 AS=0.495 PS=2
M1820 575 242 778 GND MN L=0.5 W=0.9 AD=0.495 PD=2.9 AS=0.495 PS=2
M1821 576 242 779 GND MN L=0.5 W=0.9 AD=0.495 PD=2.9 AS=0.495 PS=2
M1822 577 242 780 GND MN L=0.5 W=0.9 AD=0.495 PD=2.9 AS=0.495 PS=2
M1823 578 242 781 GND MN L=0.5 W=0.9 AD=0.495 PD=2.9 AS=0.495 PS=2
M1824 579 242 782 GND MN L=0.5 W=0.9 AD=0.2475 PD=1.45 AS=0.99 PS=4
M1825 P<1> 589 GND GND MN L=0.5 W=0.9 AD=1.2825 PD=3.75 AS=1.125 PS=4.3
M1826 P<2> 590 GND GND MN L=0.5 W=0.9 AD=1.2825 PD=3.75 AS=1.125 PS=4.3
M1827 P<3> 591 GND GND MN L=0.5 W=0.9 AD=1.2825 PD=3.75 AS=1.125 PS=4.3
M1828 P<4> 592 GND GND MN L=0.5 W=0.9 AD=1.2825 PD=3.75 AS=1.125 PS=4.3
M1829 P<5> 593 GND GND MN L=0.5 W=0.9 AD=1.2825 PD=3.75 AS=1.125 PS=4.3
M1830 P<6> 594 GND GND MN L=0.5 W=0.9 AD=1.2825 PD=3.75 AS=1.125 PS=4.3
M1831 P<7> 595 GND GND MN L=0.5 W=0.9 AD=1.2825 PD=3.75 AS=1.125 PS=4.3
M1832 P<8> 596 GND GND MN L=0.5 W=0.9 AD=1.2825 PD=3.75 AS=1.125 PS=4.3
M1833 783 GND P<1> GND MN L=0.5 W=0.9 AD=0.5625 PD=2.15 AS=0.495 PS=2.9
M1834 784 245 P<2> GND MN L=0.5 W=0.9 AD=0.5625 PD=2.15 AS=0.495 PS=2.9
M1835 785 246 P<3> GND MN L=0.5 W=0.9 AD=0.5625 PD=2.15 AS=0.495 PS=2.9
M1836 786 247 P<4> GND MN L=0.5 W=0.9 AD=0.5625 PD=2.15 AS=0.495 PS=2.9
M1837 787 248 P<5> GND MN L=0.5 W=0.9 AD=0.5625 PD=2.15 AS=0.495 PS=2.9
M1838 788 249 P<6> GND MN L=0.5 W=0.9 AD=0.5625 PD=2.15 AS=0.495 PS=2.9
M1839 789 250 P<7> GND MN L=0.5 W=0.9 AD=0.5625 PD=2.15 AS=0.495 PS=2.9
M1840 790 251 P<8> GND MN L=0.5 W=0.9 AD=0.5625 PD=2.15 AS=0.495 PS=2.9
M1841 GND 605 P<0> GND MN L=0.5 W=0.9 AD=0.4725 PD=1.95 AS=1.935 PS=6.1
M1842 597 218 GND GND MN L=0.5 W=0.9 AD=2.565 PD=7.5 AS=0.5625 PS=2.15
M1843 598 210 GND GND MN L=0.5 W=0.9 AD=2.565 PD=7.5 AS=0.5625 PS=2.15
M1844 599 211 GND GND MN L=0.5 W=0.9 AD=2.565 PD=7.5 AS=0.5625 PS=2.15
M1845 600 212 GND GND MN L=0.5 W=0.9 AD=2.565 PD=7.5 AS=0.5625 PS=2.15
M1846 601 213 GND GND MN L=0.5 W=0.9 AD=2.565 PD=7.5 AS=0.5625 PS=2.15
M1847 602 214 GND GND MN L=0.5 W=0.9 AD=2.565 PD=7.5 AS=0.5625 PS=2.15
M1848 603 215 GND GND MN L=0.5 W=0.9 AD=2.565 PD=7.5 AS=0.5625 PS=2.15
M1849 604 216 GND GND MN L=0.5 W=0.9 AD=2.565 PD=7.5 AS=0.5625 PS=2.15
M1850 791 27 GND GND MN L=0.5 W=0.9 AD=0.9675 PD=3.05 AS=0.495 PS=2.9
M1851 GND 260 783 GND MN L=0.5 W=0.9 AD=0.2475 PD=1.45 AS=1.935 PS=6.1
M1852 GND 261 784 GND MN L=0.5 W=0.9 AD=0.2475 PD=1.45 AS=1.935 PS=6.1
M1853 GND 262 785 GND MN L=0.5 W=0.9 AD=0.2475 PD=1.45 AS=1.935 PS=6.1
M1854 GND 263 786 GND MN L=0.5 W=0.9 AD=0.2475 PD=1.45 AS=1.935 PS=6.1
M1855 GND 264 787 GND MN L=0.5 W=0.9 AD=0.2475 PD=1.45 AS=1.935 PS=6.1
M1856 GND 265 788 GND MN L=0.5 W=0.9 AD=0.2475 PD=1.45 AS=1.935 PS=6.1
M1857 GND 266 789 GND MN L=0.5 W=0.9 AD=0.495 PD=2.9 AS=0.9675 PS=3.05
M1858 GND 267 790 GND MN L=0.5 W=0.9 AD=0.495 PD=2.9 AS=0.9675 PS=3.05
M1859 GND 252 597 GND MN L=0.5 W=0.9 AD=1.125 PD=4.3 AS=0.9675 PS=3.05
M1860 GND 253 598 GND MN L=0.5 W=0.9 AD=1.125 PD=4.3 AS=0.9675 PS=3.05
M1861 GND 254 599 GND MN L=0.5 W=0.9 AD=1.125 PD=4.3 AS=0.9675 PS=3.05
M1862 GND 255 600 GND MN L=0.5 W=0.9 AD=1.125 PD=4.3 AS=0.9675 PS=3.05
M1863 GND 256 601 GND MN L=0.5 W=0.9 AD=1.125 PD=4.3 AS=0.9675 PS=3.05
M1864 GND 257 602 GND MN L=0.5 W=0.9 AD=1.125 PD=4.3 AS=0.9675 PS=3.05
M1865 GND 258 603 GND MN L=0.5 W=0.9 AD=0.5625 PD=2.15 AS=1.935 PS=6.1
M1866 GND GND 604 GND MN L=0.5 W=0.9 AD=0.5625 PD=2.15 AS=1.935 PS=6.1
M1867 605 259 791 GND MN L=0.5 W=0.9 AD=0.2475 PD=1.45 AS=0.99 PS=4
M1868 792 218 GND GND MN L=0.5 W=0.9 AD=0.9675 PD=3.05 AS=0.495 PS=2.9
M1869 793 210 GND GND MN L=0.5 W=0.9 AD=0.9675 PD=3.05 AS=0.495 PS=2.9
M1870 794 211 GND GND MN L=0.5 W=0.9 AD=0.9675 PD=3.05 AS=0.495 PS=2.9
M1871 795 212 GND GND MN L=0.5 W=0.9 AD=0.9675 PD=3.05 AS=0.495 PS=2.9
M1872 796 213 GND GND MN L=0.5 W=0.9 AD=0.9675 PD=3.05 AS=0.495 PS=2.9
M1873 797 214 GND GND MN L=0.5 W=0.9 AD=0.9675 PD=3.05 AS=0.495 PS=2.9
M1874 798 215 GND GND MN L=0.5 W=0.9 AD=1.935 PD=6.1 AS=0.2475 PS=1.45
M1875 799 216 GND GND MN L=0.5 W=0.9 AD=1.935 PD=6.1 AS=0.2475 PS=1.45
M1876 589 GND GND GND MN L=0.5 W=0.9 AD=1.935 PD=6.1 AS=0.5625 PS=2.15
M1877 590 245 GND GND MN L=0.5 W=0.9 AD=1.935 PD=6.1 AS=0.5625 PS=2.15
M1878 591 246 GND GND MN L=0.5 W=0.9 AD=1.935 PD=6.1 AS=0.5625 PS=2.15
M1879 592 247 GND GND MN L=0.5 W=0.9 AD=1.935 PD=6.1 AS=0.5625 PS=2.15
M1880 593 248 GND GND MN L=0.5 W=0.9 AD=1.935 PD=6.1 AS=0.5625 PS=2.15
M1881 594 249 GND GND MN L=0.5 W=0.9 AD=1.935 PD=6.1 AS=0.5625 PS=2.15
M1882 595 250 GND GND MN L=0.5 W=0.9 AD=0.9675 PD=3.05 AS=1.125 PS=4.3
M1883 596 251 GND GND MN L=0.5 W=0.9 AD=0.9675 PD=3.05 AS=1.125 PS=4.3
M1884 GND 260 589 GND MN L=0.5 W=0.9 AD=0.5625 PD=2.15 AS=2.565 PS=7.5
M1885 GND 261 590 GND MN L=0.5 W=0.9 AD=0.5625 PD=2.15 AS=2.565 PS=7.5
M1886 GND 262 591 GND MN L=0.5 W=0.9 AD=0.5625 PD=2.15 AS=2.565 PS=7.5
M1887 GND 263 592 GND MN L=0.5 W=0.9 AD=0.5625 PD=2.15 AS=2.565 PS=7.5
M1888 GND 264 593 GND MN L=0.5 W=0.9 AD=0.5625 PD=2.15 AS=2.565 PS=7.5
M1889 GND 265 594 GND MN L=0.5 W=0.9 AD=0.5625 PD=2.15 AS=2.565 PS=7.5
M1890 GND 266 595 GND MN L=0.5 W=0.9 AD=0.5625 PD=2.15 AS=2.565 PS=7.5
M1891 GND 267 596 GND MN L=0.5 W=0.9 AD=0.5625 PD=2.15 AS=2.565 PS=7.5
M1892 260 252 792 GND MN L=0.5 W=0.9 AD=0.2475 PD=1.45 AS=1.125 PS=4.3
M1893 261 253 793 GND MN L=0.5 W=0.9 AD=0.2475 PD=1.45 AS=1.125 PS=4.3
M1894 262 254 794 GND MN L=0.5 W=0.9 AD=0.2475 PD=1.45 AS=1.125 PS=4.3
M1895 263 255 795 GND MN L=0.5 W=0.9 AD=0.2475 PD=1.45 AS=1.125 PS=4.3
M1896 264 256 796 GND MN L=0.5 W=0.9 AD=0.2475 PD=1.45 AS=1.125 PS=4.3
M1897 265 257 797 GND MN L=0.5 W=0.9 AD=0.2475 PD=1.45 AS=1.125 PS=4.3
M1898 266 258 798 GND MN L=0.5 W=0.9 AD=0.2475 PD=1.45 AS=1.125 PS=4.3
M1899 267 GND 799 GND MN L=0.5 W=0.9 AD=0.2475 PD=1.45 AS=1.125 PS=4.3
M1900 GND 597 260 GND MN L=0.5 W=0.9 AD=0.5625 PD=2.15 AS=2.565 PS=7.5
M1901 GND 598 261 GND MN L=0.5 W=0.9 AD=0.5625 PD=2.15 AS=2.565 PS=7.5
M1902 GND 599 262 GND MN L=0.5 W=0.9 AD=0.5625 PD=2.15 AS=2.565 PS=7.5
M1903 GND 600 263 GND MN L=0.5 W=0.9 AD=0.5625 PD=2.15 AS=2.565 PS=7.5
M1904 GND 601 264 GND MN L=0.5 W=0.9 AD=0.5625 PD=2.15 AS=2.565 PS=7.5
M1905 GND 602 265 GND MN L=0.5 W=0.9 AD=0.5625 PD=2.15 AS=2.565 PS=7.5
M1906 GND 603 266 GND MN L=0.5 W=0.9 AD=0.5625 PD=2.15 AS=2.565 PS=7.5
M1907 GND 604 267 GND MN L=0.5 W=0.9 AD=0.5625 PD=2.15 AS=2.565 PS=7.5
M1908 259 622 GND GND MN L=0.5 W=0.9 AD=1.8 PD=5.8 AS=0.5625 PS=2.15
M1909 614 260 GND GND MN L=0.5 W=0.9 AD=0.99 PD=4 AS=0.945 PS=3.9
M1910 615 261 GND GND MN L=0.5 W=0.9 AD=0.99 PD=4 AS=0.945 PS=3.9
M1911 616 262 GND GND MN L=0.5 W=0.9 AD=0.99 PD=4 AS=0.945 PS=3.9
M1912 617 263 GND GND MN L=0.5 W=0.9 AD=0.99 PD=4 AS=0.945 PS=3.9
M1913 618 264 GND GND MN L=0.5 W=0.9 AD=0.99 PD=4 AS=0.4725 PS=1.95
M1914 619 265 GND GND MN L=0.5 W=0.9 AD=0.99 PD=4 AS=0.4725 PS=1.95
M1915 620 266 GND GND MN L=0.5 W=0.9 AD=0.99 PD=4 AS=0.4725 PS=1.95
M1916 621 267 GND GND MN L=0.5 W=0.9 AD=0.99 PD=4 AS=0.4725 PS=1.95
M1917 GND 622 259 GND MN L=0.5 W=0.9 AD=1.125 PD=4.3 AS=0.9675 PS=3.05
M1918 622 A<0> GND GND MN L=0.5 W=0.9 AD=0.9675 PD=3.05 AS=0.99 PS=4
M1919 GND 623 252 GND MN L=0.5 W=0.9 AD=0.4725 PD=1.95 AS=1.935 PS=6.1
M1920 GND 624 253 GND MN L=0.5 W=0.9 AD=0.4725 PD=1.95 AS=1.935 PS=6.1
M1921 GND 625 254 GND MN L=0.5 W=0.9 AD=0.4725 PD=1.95 AS=1.935 PS=6.1
M1922 GND 626 255 GND MN L=0.5 W=0.9 AD=0.4725 PD=1.95 AS=1.935 PS=6.1
M1923 GND 627 256 GND MN L=0.5 W=0.9 AD=0.4725 PD=1.95 AS=1.935 PS=6.1
M1924 GND 628 257 GND MN L=0.5 W=0.9 AD=0.4725 PD=1.95 AS=1.935 PS=6.1
M1925 GND 629 258 GND MN L=0.5 W=0.9 AD=0.4725 PD=1.95 AS=1.935 PS=6.1
M1926 800 28 GND GND MN L=0.5 W=0.9 AD=1.935 PD=6.1 AS=0.2475 PS=1.45
M1927 801 29 GND GND MN L=0.5 W=0.9 AD=1.935 PD=6.1 AS=0.2475 PS=1.45
M1928 802 30 GND GND MN L=0.5 W=0.9 AD=1.935 PD=6.1 AS=0.2475 PS=1.45
M1929 803 31 GND GND MN L=0.5 W=0.9 AD=1.935 PD=6.1 AS=0.2475 PS=1.45
M1930 804 32 GND GND MN L=0.5 W=0.9 AD=0.9675 PD=3.05 AS=0.495 PS=2.9
M1931 805 33 GND GND MN L=0.5 W=0.9 AD=0.9675 PD=3.05 AS=0.495 PS=2.9
M1932 806 34 GND GND MN L=0.5 W=0.9 AD=0.9675 PD=3.05 AS=0.495 PS=2.9
M1933 245 614 252 GND MN L=0.5 W=0.9 AD=0.495 PD=2 AS=1.125 PS=4.3
M1934 246 615 253 GND MN L=0.5 W=0.9 AD=0.495 PD=2 AS=1.125 PS=4.3
M1935 247 616 254 GND MN L=0.5 W=0.9 AD=0.495 PD=2 AS=1.125 PS=4.3
M1936 248 617 255 GND MN L=0.5 W=0.9 AD=0.495 PD=2 AS=1.125 PS=4.3
M1937 249 618 256 GND MN L=0.5 W=0.9 AD=0.495 PD=2 AS=1.125 PS=4.3
M1938 250 619 257 GND MN L=0.5 W=0.9 AD=0.99 PD=4 AS=0.5625 PS=2.15
M1939 251 620 258 GND MN L=0.5 W=0.9 AD=0.99 PD=4 AS=0.5625 PS=2.15
M1940 226 621 GND GND MN L=0.5 W=0.9 AD=0.99 PD=4 AS=0.5625 PS=2.15
M1941 GND 260 245 GND MN L=0.5 W=0.9 AD=0.5625 PD=2.15 AS=0.945 PS=3.9
M1942 245 261 246 GND MN L=0.5 W=0.9 AD=0.5625 PD=2.15 AS=0.945 PS=3.9
M1943 246 262 247 GND MN L=0.5 W=0.9 AD=0.5625 PD=2.15 AS=0.945 PS=3.9
M1944 247 263 248 GND MN L=0.5 W=0.9 AD=0.5625 PD=2.15 AS=0.945 PS=3.9
M1945 248 264 249 GND MN L=0.5 W=0.9 AD=0.5625 PD=2.15 AS=0.945 PS=3.9
M1946 249 265 250 GND MN L=0.5 W=0.9 AD=0.5625 PD=2.15 AS=0.945 PS=3.9
M1947 250 266 251 GND MN L=0.5 W=0.9 AD=0.5625 PD=2.15 AS=0.945 PS=3.9
M1948 251 267 226 GND MN L=0.5 W=0.9 AD=0.5625 PD=2.15 AS=0.945 PS=3.9
M1949 623 259 800 GND MN L=0.5 W=0.9 AD=0.2475 PD=1.45 AS=0.99 PS=4
M1950 624 259 801 GND MN L=0.5 W=0.9 AD=0.2475 PD=1.45 AS=0.99 PS=4
M1951 625 259 802 GND MN L=0.5 W=0.9 AD=0.2475 PD=1.45 AS=0.99 PS=4
M1952 626 259 803 GND MN L=0.5 W=0.9 AD=0.2475 PD=1.45 AS=0.99 PS=4
M1953 627 259 804 GND MN L=0.5 W=0.9 AD=0.2475 PD=1.45 AS=0.99 PS=4
M1954 628 259 805 GND MN L=0.5 W=0.9 AD=0.2475 PD=1.45 AS=0.99 PS=4
M1955 629 259 806 GND MN L=0.5 W=0.9 AD=0.495 PD=2.9 AS=0.495 PS=2

.OPTION CONVERGE=1
*.options post probe=0
.options device scale=1u
.option scale=1u
*.GLOBAL  VDD GND gnd vdd

vss gnd 0 0
vdd VDD 0 1.8v

vA<0> A<0> 0 0v
vA<1> A<1> 0 0v
vA<2> A<2> 0 0v
vA<3> A<3> 0 0v
vA<4> A<4> 0 pulse 0 1.8v 5n 0.1n 0.1n 12.5n 25n
vA<5> A<5> 0 0v
vA<6> A<6> 0 0v
vA<7> A<7> 0 0v

vB<0> B<0> 0 0v
vB<1> B<1> 0 pulse 0 1.8v 5n 0.1n 0.1n 12.5n 25n
vB<2> B<2> 0 pulse 0 1.8v 5n 0.1n 0.1n 12.5n 25n
vB<3> B<3> 0 0v
vB<4> B<4> 0 0v
vB<5> B<5> 0 0v
vB<6> B<6> 0 0v
vB<7> B<7> 0 0v

*.meas tran tP5r trig v(A<4>) val=2.5 rise=3
*+ targ v(P<5>) val=2.5 rise=3
*.meas tran tP5f trig v(A<4>) val=2.5 fall=2
*+ targ v(P<5>) val=2.5 fall=2

.inc model.inc
*.lib '/home/yangfan/development/mor_clean/test_case/MUL8x8/mul8x8_model/mtp580_para.lib_r002' NN
.tran 0.1n 100n
.print V(P<5>)
.END
