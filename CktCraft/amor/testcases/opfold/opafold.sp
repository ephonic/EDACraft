* test opafold
rf FOLDOUT INN 10g
CINN INN VSS 10
VINPUT INP VSS 0.94 sin 0.94 9u 8
VDD VDD VSS 1.8
VSS VSS 0 0
vpdb PDB VSS 1.8
cload FOLDOUT VSS 30E-12
R0 NET_0111 NET_0180  25E3
MB14 NET_0116 NET_170 NET_182 VSS  N18  L=1.5E-6 W=3E-6 M=2.0
MB3 NET_170 NET_170 NET_178 VSS  N18  L=3E-6 W=2.3E-6 M=1.0
MB15 NET_182 NET_0149 VSS VSS  N18  L=3E-6 W=3E-6 M=2.0
M4 NET_268 NET_0149 VSS VSS  N18  L=3E-6 W=3E-6 M=4.0
MB9 NET_174 NET_170 NET_0141 VSS  N18  L=1.5E-6 W=3E-6 M=2.0
MB4 NET_178 NET_170 VSS VSS  N18  L=3E-6 W=2.3E-6 M=1.0
MB6 NET_0149 NET_170 NET_190 VSS  N18  L=1.5E-6 W=3E-6 M=2.0
M6 FOLDOUT NET_170 NET_268 VSS  N18  L=1.5E-6 W=3E-6 M=2.0
M5 NET7 NET_170 NET_264 VSS  N18  L=1.5E-6 W=3E-6 M=2.0
M3 NET_264 NET_0149 VSS VSS  N18  L=3E-6 W=3E-6 M=4.0
MB8 NET_0141 NET_0149 VSS VSS  N18  L=3E-6 W=3E-6 M=2.0
MB7 NET_190 NET_0149 VSS VSS  N18  L=3E-6 W=3E-6 M=2.0
MB1 NET_0111 NET_0111 VDD VDD  P18  L=4E-6 W=2E-6 M=2.0
MB5 NET_0149 NET_0111 VDD VDD  P18  L=4E-6 W=2E-6 M=2.0
MB2 NET_170 NET_0111 VDD VDD  P18  L=4E-6 W=2E-6 M=2.0
MPD1 NET_0180 PDB VSS VSS  N18  L=180E-9 W=1E-6 M=1.0
MB11 NET_231 NET_174 VDD VDD  P18  L=2.5E-6 W=9.5E-6 M=1.0
MB10 NET_174 NET_174 NET_231 VDD  P18  L=2.5E-6 W=9.5E-6 M=1.0
MB12 NET_0183 NET_0116 VDD VDD  P18  L=2.5E-6 W=12E-6 M=2.0
M10 NET_275 NET7 VDD VDD  P18  L=2.5E-6 W=12E-6 M=2.0
MB13 NET_0116 NET_174 NET_0183 VDD  P18  L=1.5E-6 W=12E-6 M=2.0
MDM2 NET249 NET249 NET249 NET249  P18  L=2E-6 W=20E-6 M=2.0
M9 NET_283 NET7 VDD VDD  P18  L=2.5E-6 W=12E-6 M=2.0
M0 NET249 NET_0116 VDD VDD  P18  L=2.5E-6 W=12E-6 M=4.0
M1 NET_264 INP NET249 NET249  P18  L=180E-9 W=5E-6 M=4.0
M2 NET_268 INN NET249 NET249  P18  L=180E-9 W=5E-6 M=4.0
M8 FOLDOUT NET_174 NET_275 VDD  P18  L=1.5E-6 W=12E-6 M=2.0
M7 NET7 NET_174 NET_283 VDD  P18  L=1.5E-6 W=12E-6 M=2.0
MDM1 NET249 NET249 NET249 NET249  P18  L=2E-6 W=20E-6 M=2.0
.inc model.inc
.op
.tran 0.1m 40
.probe v(foldout)
.print tran v(foldout)
.end
