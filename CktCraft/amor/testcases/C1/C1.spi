*.circuit C1

*.FLATTENED
* Special Nodes :
* IN1 9
* VDD 1
* GND 2
* O69 80
* O68 79
* O67 78
* O66 77
* O65 76
* O1 4
* O2 5
* O3 6
* O4 7
* O5 8
* O6 10
* O7 11
* O8 12
* O9 13
* O10 14
* O11 15
* O12 16
* O13 17
* O14 18
* O15 19
* O16 20
* O17 23
* O18 24
* O19 25
* O20 26
* O21 27
* O22 28
* O23 29
* O24 30
* O25 31
* O26 32
* O27 33
* O28 34
* O29 36
* O30 37
* O31 38
* O32 39
* O33 42
* O34 43
* O35 44
* O36 45
* O37 46
* O38 47
* O39 48
* O40 49
* O41 50
* O42 51
* O43 52
* O44 54
* O45 55
* O46 56
* O47 57
* O48 58
* O49 59
* O50 60
* O51 61
* O52 62
* O53 63
* O54 64
* O55 65
* O56 66
* O57 67
* O58 68
* O59 69
* O60 71
* O61 72
* O62 73
* O63 74
* O64 75
*
M0 O1 3 VDD VDD P L=0.54 W=3 AD=2.7 PD=7.8 AS=1.5 PS=4
M1 VDD 3 O1 VDD P L=0.54 W=3 AD=1.5 PD=4 AS=3 PS=8
M2 O1 3 VDD VDD P L=0.54 W=3 AD=1.5 PD=4 AS=3 PS=8
M3 VDD 3 O1 VDD P L=0.54 W=3 AD=1.5 PD=4 AS=3 PS=8
M4 O1 3 VDD VDD P L=0.54 W=3 AD=1.5 PD=4 AS=3 PS=8
M5 VDD 3 O1 VDD P L=0.54 W=3 AD=1.5 PD=4 AS=2.7 PS=7.8
M6 O2 3 VDD VDD P L=0.54 W=3 AD=2.7 PD=7.8 AS=1.5 PS=4
M7 VDD 3 O2 VDD P L=0.54 W=3 AD=1.5 PD=4 AS=3 PS=8
M8 O2 3 VDD VDD P L=0.54 W=3 AD=1.5 PD=4 AS=3 PS=8
M9 VDD 3 O2 VDD P L=0.54 W=3 AD=1.5 PD=4 AS=3 PS=8
M10 O2 3 VDD VDD P L=0.54 W=3 AD=1.5 PD=4 AS=3 PS=8
M11 VDD 3 O2 VDD P L=0.54 W=3 AD=1.5 PD=4 AS=2.7 PS=7.8
M12 O3 3 VDD VDD P L=0.54 W=3 AD=2.7 PD=7.8 AS=1.5 PS=4
M13 VDD 3 O3 VDD P L=0.54 W=3 AD=1.5 PD=4 AS=3 PS=8
M14 O3 3 VDD VDD P L=0.54 W=3 AD=1.5 PD=4 AS=3 PS=8
M15 VDD 3 O3 VDD P L=0.54 W=3 AD=1.5 PD=4 AS=3 PS=8
M16 O3 3 VDD VDD P L=0.54 W=3 AD=1.5 PD=4 AS=3 PS=8
M17 VDD 3 O3 VDD P L=0.54 W=3 AD=1.5 PD=4 AS=2.7 PS=7.8
M18 O4 3 VDD VDD P L=0.54 W=3 AD=2.7 PD=7.8 AS=1.5 PS=4
M19 VDD 3 O4 VDD P L=0.54 W=3 AD=1.5 PD=4 AS=3 PS=8
M20 O4 3 VDD VDD P L=0.54 W=3 AD=1.5 PD=4 AS=3 PS=8
M21 VDD 3 O4 VDD P L=0.54 W=3 AD=1.5 PD=4 AS=3 PS=8
M22 O4 3 VDD VDD P L=0.54 W=3 AD=1.5 PD=4 AS=3 PS=8
M23 VDD 3 O4 VDD P L=0.54 W=3 AD=1.5 PD=4 AS=2.7 PS=7.8
M24 O5 3 VDD VDD P L=0.54 W=3 AD=2.7 PD=7.8 AS=1.5 PS=4
M25 VDD 3 O5 VDD P L=0.54 W=3 AD=1.5 PD=4 AS=3 PS=8
M26 O5 3 VDD VDD P L=0.54 W=3 AD=1.5 PD=4 AS=3 PS=8
M27 VDD 3 O5 VDD P L=0.54 W=3 AD=1.5 PD=4 AS=3 PS=8
M28 O5 3 VDD VDD P L=0.54 W=3 AD=1.5 PD=4 AS=3 PS=8
M29 VDD 3 O5 VDD P L=0.54 W=3 AD=1.5 PD=4 AS=2.7 PS=7.8
M30 3 IN1 VDD VDD P L=0.54 W=3 AD=1.5 PD=7 AS=1.5 PS=4
M31 VDD IN1 3 VDD P L=0.54 W=3 AD=1.5 PD=4 AS=3 PS=8
M32 3 IN1 VDD VDD P L=0.54 W=3 AD=1.5 PD=4 AS=3 PS=8
M33 VDD IN1 3 VDD P L=0.54 W=3 AD=1.5 PD=4 AS=1.5 PS=7
M34 O6 3 VDD VDD P L=0.54 W=3 AD=2.7 PD=7.8 AS=1.5 PS=4
M35 VDD 3 O6 VDD P L=0.54 W=3 AD=1.5 PD=4 AS=3 PS=8
M36 O6 3 VDD VDD P L=0.54 W=3 AD=1.5 PD=4 AS=3 PS=8
M37 VDD 3 O6 VDD P L=0.54 W=3 AD=1.5 PD=4 AS=3 PS=8
M38 O6 3 VDD VDD P L=0.54 W=3 AD=1.5 PD=4 AS=3 PS=8
M39 VDD 3 O6 VDD P L=0.54 W=3 AD=1.5 PD=4 AS=2.7 PS=7.8
M40 O7 3 VDD VDD P L=0.54 W=3 AD=2.7 PD=7.8 AS=1.5 PS=4
M41 VDD 3 O7 VDD P L=0.54 W=3 AD=1.5 PD=4 AS=3 PS=8
M42 O7 3 VDD VDD P L=0.54 W=3 AD=1.5 PD=4 AS=3 PS=8
M43 VDD 3 O7 VDD P L=0.54 W=3 AD=1.5 PD=4 AS=3 PS=8
M44 O7 3 VDD VDD P L=0.54 W=3 AD=1.5 PD=4 AS=3 PS=8
M45 VDD 3 O7 VDD P L=0.54 W=3 AD=1.5 PD=4 AS=2.7 PS=7.8
M46 O8 3 VDD VDD P L=0.54 W=3 AD=2.7 PD=7.8 AS=1.5 PS=4
M47 VDD 3 O8 VDD P L=0.54 W=3 AD=1.5 PD=4 AS=3 PS=8
M48 O8 3 VDD VDD P L=0.54 W=3 AD=1.5 PD=4 AS=3 PS=8
M49 VDD 3 O8 VDD P L=0.54 W=3 AD=1.5 PD=4 AS=3 PS=8
M50 O8 3 VDD VDD P L=0.54 W=3 AD=1.5 PD=4 AS=3 PS=8
M51 VDD 3 O8 VDD P L=0.54 W=3 AD=1.5 PD=4 AS=2.7 PS=7.8
M52 O9 3 VDD VDD P L=0.54 W=3 AD=2.7 PD=7.8 AS=1.5 PS=4
M53 VDD 3 O9 VDD P L=0.54 W=3 AD=1.5 PD=4 AS=3 PS=8
M54 O9 3 VDD VDD P L=0.54 W=3 AD=1.5 PD=4 AS=3 PS=8
M55 VDD 3 O9 VDD P L=0.54 W=3 AD=1.5 PD=4 AS=3 PS=8
M56 O9 3 VDD VDD P L=0.54 W=3 AD=1.5 PD=4 AS=3 PS=8
M57 VDD 3 O9 VDD P L=0.54 W=3 AD=1.5 PD=4 AS=2.7 PS=7.8
M58 O10 3 VDD VDD P L=0.54 W=3 AD=2.7 PD=7.8 AS=1.5 PS=4
M59 VDD 3 O10 VDD P L=0.54 W=3 AD=1.5 PD=4 AS=3 PS=8
M60 O10 3 VDD VDD P L=0.54 W=3 AD=1.5 PD=4 AS=3 PS=8
M61 VDD 3 O10 VDD P L=0.54 W=3 AD=1.5 PD=4 AS=3 PS=8
M62 O10 3 VDD VDD P L=0.54 W=3 AD=1.5 PD=4 AS=3 PS=8
M63 VDD 3 O10 VDD P L=0.54 W=3 AD=1.5 PD=4 AS=2.7 PS=7.8
M64 O11 3 VDD VDD P L=0.54 W=3 AD=2.7 PD=7.8 AS=1.5 PS=4
M65 VDD 3 O11 VDD P L=0.54 W=3 AD=1.5 PD=4 AS=3 PS=8
M66 O11 3 VDD VDD P L=0.54 W=3 AD=1.5 PD=4 AS=3 PS=8
M67 VDD 3 O11 VDD P L=0.54 W=3 AD=1.5 PD=4 AS=3 PS=8
M68 O11 3 VDD VDD P L=0.54 W=3 AD=1.5 PD=4 AS=3 PS=8
M69 VDD 3 O11 VDD P L=0.54 W=3 AD=1.5 PD=4 AS=2.7 PS=7.8
M70 O12 3 VDD VDD P L=0.54 W=3 AD=2.7 PD=7.8 AS=1.5 PS=4
M71 VDD 3 O12 VDD P L=0.54 W=3 AD=1.5 PD=4 AS=3 PS=8
M72 O12 3 VDD VDD P L=0.54 W=3 AD=1.5 PD=4 AS=3 PS=8
M73 VDD 3 O12 VDD P L=0.54 W=3 AD=1.5 PD=4 AS=3 PS=8
M74 O12 3 VDD VDD P L=0.54 W=3 AD=1.5 PD=4 AS=3 PS=8
M75 VDD 3 O12 VDD P L=0.54 W=3 AD=1.5 PD=4 AS=2.7 PS=7.8
M76 O13 3 VDD VDD P L=0.54 W=3 AD=2.7 PD=7.8 AS=1.5 PS=4
M77 VDD 3 O13 VDD P L=0.54 W=3 AD=1.5 PD=4 AS=3 PS=8
M78 O13 3 VDD VDD P L=0.54 W=3 AD=1.5 PD=4 AS=3 PS=8
M79 VDD 3 O13 VDD P L=0.54 W=3 AD=1.5 PD=4 AS=3 PS=8
M80 O13 3 VDD VDD P L=0.54 W=3 AD=1.5 PD=4 AS=3 PS=8
M81 VDD 3 O13 VDD P L=0.54 W=3 AD=1.5 PD=4 AS=2.7 PS=7.8
M82 O14 3 VDD VDD P L=0.54 W=3 AD=2.7 PD=7.8 AS=1.5 PS=4
M83 VDD 3 O14 VDD P L=0.54 W=3 AD=1.5 PD=4 AS=3 PS=8
M84 O14 3 VDD VDD P L=0.54 W=3 AD=1.5 PD=4 AS=3 PS=8
M85 VDD 3 O14 VDD P L=0.54 W=3 AD=1.5 PD=4 AS=3 PS=8
M86 O14 3 VDD VDD P L=0.54 W=3 AD=1.5 PD=4 AS=3 PS=8
M87 VDD 3 O14 VDD P L=0.54 W=3 AD=1.5 PD=4 AS=2.7 PS=7.8
M88 O15 3 VDD VDD P L=0.54 W=3 AD=2.7 PD=7.8 AS=1.5 PS=4
M89 VDD 3 O15 VDD P L=0.54 W=3 AD=1.5 PD=4 AS=3 PS=8
M90 O15 3 VDD VDD P L=0.54 W=3 AD=1.5 PD=4 AS=3 PS=8
M91 VDD 3 O15 VDD P L=0.54 W=3 AD=1.5 PD=4 AS=3 PS=8
M92 O15 3 VDD VDD P L=0.54 W=3 AD=1.5 PD=4 AS=3 PS=8
M93 VDD 3 O15 VDD P L=0.54 W=3 AD=1.5 PD=4 AS=2.7 PS=7.8
M94 O16 3 VDD VDD P L=0.54 W=3 AD=2.7 PD=7.8 AS=1.5 PS=4
M95 VDD 3 O16 VDD P L=0.54 W=3 AD=1.5 PD=4 AS=3 PS=8
M96 O16 3 VDD VDD P L=0.54 W=3 AD=1.5 PD=4 AS=3 PS=8
M97 VDD 3 O16 VDD P L=0.54 W=3 AD=1.5 PD=4 AS=3 PS=8
M98 O16 3 VDD VDD P L=0.54 W=3 AD=1.5 PD=4 AS=3 PS=8
M99 VDD 3 O16 VDD P L=0.54 W=3 AD=1.5 PD=4 AS=2.7 PS=7.8
M100 O17 3 VDD VDD P L=0.54 W=3 AD=2.7 PD=7.8 AS=1.5 PS=4
M101 VDD 3 O17 VDD P L=0.54 W=3 AD=1.5 PD=4 AS=3 PS=8
M102 O17 3 VDD VDD P L=0.54 W=3 AD=1.5 PD=4 AS=3 PS=8
M103 VDD 3 O17 VDD P L=0.54 W=3 AD=1.5 PD=4 AS=3 PS=8
M104 O17 3 VDD VDD P L=0.54 W=3 AD=1.5 PD=4 AS=3 PS=8
M105 VDD 3 O17 VDD P L=0.54 W=3 AD=1.5 PD=4 AS=2.7 PS=7.8
M106 O18 3 VDD VDD P L=0.54 W=3 AD=2.7 PD=7.8 AS=1.5 PS=4
M107 VDD 3 O18 VDD P L=0.54 W=3 AD=1.5 PD=4 AS=3 PS=8
M108 O18 3 VDD VDD P L=0.54 W=3 AD=1.5 PD=4 AS=3 PS=8
M109 VDD 3 O18 VDD P L=0.54 W=3 AD=1.5 PD=4 AS=3 PS=8
M110 O18 3 VDD VDD P L=0.54 W=3 AD=1.5 PD=4 AS=3 PS=8
M111 VDD 3 O18 VDD P L=0.54 W=3 AD=1.5 PD=4 AS=2.7 PS=7.8
M112 O19 3 VDD VDD P L=0.54 W=3 AD=2.7 PD=7.8 AS=1.5 PS=4
M113 VDD 3 O19 VDD P L=0.54 W=3 AD=1.5 PD=4 AS=3 PS=8
M114 O19 3 VDD VDD P L=0.54 W=3 AD=1.5 PD=4 AS=3 PS=8
M115 VDD 3 O19 VDD P L=0.54 W=3 AD=1.5 PD=4 AS=3 PS=8
M116 O19 3 VDD VDD P L=0.54 W=3 AD=1.5 PD=4 AS=3 PS=8
M117 VDD 3 O19 VDD P L=0.54 W=3 AD=1.5 PD=4 AS=2.7 PS=7.8
M118 O20 3 VDD VDD P L=0.54 W=3 AD=2.7 PD=7.8 AS=1.5 PS=4
M119 VDD 3 O20 VDD P L=0.54 W=3 AD=1.5 PD=4 AS=3 PS=8
M120 O20 3 VDD VDD P L=0.54 W=3 AD=1.5 PD=4 AS=3 PS=8
M121 VDD 3 O20 VDD P L=0.54 W=3 AD=1.5 PD=4 AS=3 PS=8
M122 O20 3 VDD VDD P L=0.54 W=3 AD=1.5 PD=4 AS=3 PS=8
M123 VDD 3 O20 VDD P L=0.54 W=3 AD=1.5 PD=4 AS=2.7 PS=7.8
M124 O21 3 VDD VDD P L=0.54 W=3 AD=2.7 PD=7.8 AS=1.5 PS=4
M125 VDD 3 O21 VDD P L=0.54 W=3 AD=1.5 PD=4 AS=3 PS=8
M126 O21 3 VDD VDD P L=0.54 W=3 AD=1.5 PD=4 AS=3 PS=8
M127 VDD 3 O21 VDD P L=0.54 W=3 AD=1.5 PD=4 AS=3 PS=8
M128 O21 3 VDD VDD P L=0.54 W=3 AD=1.5 PD=4 AS=3 PS=8
M129 VDD 3 O21 VDD P L=0.54 W=3 AD=1.5 PD=4 AS=2.7 PS=7.8
M130 O22 3 VDD VDD P L=0.54 W=3 AD=2.7 PD=7.8 AS=1.5 PS=4
M131 VDD 3 O22 VDD P L=0.54 W=3 AD=1.5 PD=4 AS=3 PS=8
M132 O22 3 VDD VDD P L=0.54 W=3 AD=1.5 PD=4 AS=3 PS=8
M133 VDD 3 O22 VDD P L=0.54 W=3 AD=1.5 PD=4 AS=3 PS=8
M134 O22 3 VDD VDD P L=0.54 W=3 AD=1.5 PD=4 AS=3 PS=8
M135 VDD 3 O22 VDD P L=0.54 W=3 AD=1.5 PD=4 AS=2.7 PS=7.8
M136 O23 3 VDD VDD P L=0.54 W=3 AD=2.7 PD=7.8 AS=1.5 PS=4
M137 VDD 3 O23 VDD P L=0.54 W=3 AD=1.5 PD=4 AS=3 PS=8
M138 O23 3 VDD VDD P L=0.54 W=3 AD=1.5 PD=4 AS=3 PS=8
M139 VDD 3 O23 VDD P L=0.54 W=3 AD=1.5 PD=4 AS=3 PS=8
M140 O23 3 VDD VDD P L=0.54 W=3 AD=1.5 PD=4 AS=3 PS=8
M141 VDD 3 O23 VDD P L=0.54 W=3 AD=1.5 PD=4 AS=2.7 PS=7.8
M142 O24 3 VDD VDD P L=0.54 W=3 AD=2.7 PD=7.8 AS=1.5 PS=4
M143 VDD 3 O24 VDD P L=0.54 W=3 AD=1.5 PD=4 AS=3 PS=8
M144 O24 3 VDD VDD P L=0.54 W=3 AD=1.5 PD=4 AS=3 PS=8
M145 VDD 3 O24 VDD P L=0.54 W=3 AD=1.5 PD=4 AS=3 PS=8
M146 O24 3 VDD VDD P L=0.54 W=3 AD=1.5 PD=4 AS=3 PS=8
M147 VDD 3 O24 VDD P L=0.54 W=3 AD=1.5 PD=4 AS=2.7 PS=7.8
M148 O25 3 VDD VDD P L=0.54 W=3 AD=2.7 PD=7.8 AS=1.5 PS=4
M149 VDD 3 O25 VDD P L=0.54 W=3 AD=1.5 PD=4 AS=3 PS=8
M150 O25 3 VDD VDD P L=0.54 W=3 AD=1.5 PD=4 AS=3 PS=8
M151 VDD 3 O25 VDD P L=0.54 W=3 AD=1.5 PD=4 AS=3 PS=8
M152 O25 3 VDD VDD P L=0.54 W=3 AD=1.5 PD=4 AS=3 PS=8
M153 VDD 3 O25 VDD P L=0.54 W=3 AD=1.5 PD=4 AS=2.7 PS=7.8
M154 O26 3 VDD VDD P L=0.54 W=3 AD=2.7 PD=7.8 AS=1.5 PS=4
M155 VDD 3 O26 VDD P L=0.54 W=3 AD=1.5 PD=4 AS=3 PS=8
M156 O26 3 VDD VDD P L=0.54 W=3 AD=1.5 PD=4 AS=3 PS=8
M157 VDD 3 O26 VDD P L=0.54 W=3 AD=1.5 PD=4 AS=3 PS=8
M158 O26 3 VDD VDD P L=0.54 W=3 AD=1.5 PD=4 AS=3 PS=8
M159 VDD 3 O26 VDD P L=0.54 W=3 AD=1.5 PD=4 AS=2.7 PS=7.8
M160 O27 3 VDD VDD P L=0.54 W=3 AD=2.7 PD=7.8 AS=1.5 PS=4
M161 VDD 3 O27 VDD P L=0.54 W=3 AD=1.5 PD=4 AS=3 PS=8
M162 O27 3 VDD VDD P L=0.54 W=3 AD=1.5 PD=4 AS=3 PS=8
M163 VDD 3 O27 VDD P L=0.54 W=3 AD=1.5 PD=4 AS=3 PS=8
M164 O27 3 VDD VDD P L=0.54 W=3 AD=1.5 PD=4 AS=3 PS=8
M165 VDD 3 O27 VDD P L=0.54 W=3 AD=1.5 PD=4 AS=2.7 PS=7.8
M166 O28 3 VDD VDD P L=0.54 W=3 AD=2.7 PD=7.8 AS=1.5 PS=4
M167 VDD 3 O28 VDD P L=0.54 W=3 AD=1.5 PD=4 AS=3 PS=8
M168 O28 3 VDD VDD P L=0.54 W=3 AD=1.5 PD=4 AS=3 PS=8
M169 VDD 3 O28 VDD P L=0.54 W=3 AD=1.5 PD=4 AS=3 PS=8
M170 O28 3 VDD VDD P L=0.54 W=3 AD=1.5 PD=4 AS=3 PS=8
M171 VDD 3 O28 VDD P L=0.54 W=3 AD=1.5 PD=4 AS=2.7 PS=7.8
M172 O29 3 VDD VDD P L=0.54 W=3 AD=2.7 PD=7.8 AS=1.5 PS=4
M173 VDD 3 O29 VDD P L=0.54 W=3 AD=1.5 PD=4 AS=3 PS=8
M174 O29 3 VDD VDD P L=0.54 W=3 AD=1.5 PD=4 AS=3 PS=8
M175 VDD 3 O29 VDD P L=0.54 W=3 AD=1.5 PD=4 AS=3 PS=8
M176 O29 3 VDD VDD P L=0.54 W=3 AD=1.5 PD=4 AS=3 PS=8
M177 VDD 3 O29 VDD P L=0.54 W=3 AD=1.5 PD=4 AS=2.7 PS=7.8
M178 O30 3 VDD VDD P L=0.54 W=3 AD=2.7 PD=7.8 AS=1.5 PS=4
M179 VDD 3 O30 VDD P L=0.54 W=3 AD=1.5 PD=4 AS=3 PS=8
M180 O30 3 VDD VDD P L=0.54 W=3 AD=1.5 PD=4 AS=3 PS=8
M181 VDD 3 O30 VDD P L=0.54 W=3 AD=1.5 PD=4 AS=3 PS=8
M182 O30 3 VDD VDD P L=0.54 W=3 AD=1.5 PD=4 AS=3 PS=8
M183 VDD 3 O30 VDD P L=0.54 W=3 AD=1.5 PD=4 AS=2.7 PS=7.8
M184 O31 3 VDD VDD P L=0.54 W=3 AD=2.7 PD=7.8 AS=1.5 PS=4
M185 VDD 3 O31 VDD P L=0.54 W=3 AD=1.5 PD=4 AS=3 PS=8
M186 O31 3 VDD VDD P L=0.54 W=3 AD=1.5 PD=4 AS=3 PS=8
M187 VDD 3 O31 VDD P L=0.54 W=3 AD=1.5 PD=4 AS=3 PS=8
M188 O31 3 VDD VDD P L=0.54 W=3 AD=1.5 PD=4 AS=3 PS=8
M189 VDD 3 O31 VDD P L=0.54 W=3 AD=1.5 PD=4 AS=2.7 PS=7.8
M190 O32 3 VDD VDD P L=0.54 W=3 AD=2.7 PD=7.8 AS=1.5 PS=4
M191 VDD 3 O32 VDD P L=0.54 W=3 AD=1.5 PD=4 AS=3 PS=8
M192 O32 3 VDD VDD P L=0.54 W=3 AD=1.5 PD=4 AS=3 PS=8
M193 VDD 3 O32 VDD P L=0.54 W=3 AD=1.5 PD=4 AS=3 PS=8
M194 O32 3 VDD VDD P L=0.54 W=3 AD=1.5 PD=4 AS=3 PS=8
M195 VDD 3 O32 VDD P L=0.54 W=3 AD=1.5 PD=4 AS=2.7 PS=7.8
M196 O33 3 VDD VDD P L=0.54 W=3 AD=2.7 PD=7.8 AS=1.5 PS=4
M197 VDD 3 O33 VDD P L=0.54 W=3 AD=1.5 PD=4 AS=3 PS=8
M198 O33 3 VDD VDD P L=0.54 W=3 AD=1.5 PD=4 AS=3 PS=8
M199 VDD 3 O33 VDD P L=0.54 W=3 AD=1.5 PD=4 AS=3 PS=8
M200 O33 3 VDD VDD P L=0.54 W=3 AD=1.5 PD=4 AS=3 PS=8
M201 VDD 3 O33 VDD P L=0.54 W=3 AD=1.5 PD=4 AS=2.7 PS=7.8
M202 O34 3 VDD VDD P L=0.54 W=3 AD=2.7 PD=7.8 AS=1.5 PS=4
M203 VDD 3 O34 VDD P L=0.54 W=3 AD=1.5 PD=4 AS=3 PS=8
M204 O34 3 VDD VDD P L=0.54 W=3 AD=1.5 PD=4 AS=3 PS=8
M205 VDD 3 O34 VDD P L=0.54 W=3 AD=1.5 PD=4 AS=3 PS=8
M206 O34 3 VDD VDD P L=0.54 W=3 AD=1.5 PD=4 AS=3 PS=8
M207 VDD 3 O34 VDD P L=0.54 W=3 AD=1.5 PD=4 AS=2.7 PS=7.8
M208 O35 3 VDD VDD P L=0.54 W=3 AD=2.7 PD=7.8 AS=1.5 PS=4
M209 VDD 3 O35 VDD P L=0.54 W=3 AD=1.5 PD=4 AS=3 PS=8
M210 O35 3 VDD VDD P L=0.54 W=3 AD=1.5 PD=4 AS=3 PS=8
M211 VDD 3 O35 VDD P L=0.54 W=3 AD=1.5 PD=4 AS=3 PS=8
M212 O35 3 VDD VDD P L=0.54 W=3 AD=1.5 PD=4 AS=3 PS=8
M213 VDD 3 O35 VDD P L=0.54 W=3 AD=1.5 PD=4 AS=2.7 PS=7.8
M214 O36 3 VDD VDD P L=0.54 W=3 AD=2.7 PD=7.8 AS=1.5 PS=4
M215 VDD 3 O36 VDD P L=0.54 W=3 AD=1.5 PD=4 AS=3 PS=8
M216 O36 3 VDD VDD P L=0.54 W=3 AD=1.5 PD=4 AS=3 PS=8
M217 VDD 3 O36 VDD P L=0.54 W=3 AD=1.5 PD=4 AS=3 PS=8
M218 O36 3 VDD VDD P L=0.54 W=3 AD=1.5 PD=4 AS=3 PS=8
M219 VDD 3 O36 VDD P L=0.54 W=3 AD=1.5 PD=4 AS=2.7 PS=7.8
M220 O37 3 VDD VDD P L=0.54 W=3 AD=2.7 PD=7.8 AS=1.5 PS=4
M221 VDD 3 O37 VDD P L=0.54 W=3 AD=1.5 PD=4 AS=3 PS=8
M222 O37 3 VDD VDD P L=0.54 W=3 AD=1.5 PD=4 AS=3 PS=8
M223 VDD 3 O37 VDD P L=0.54 W=3 AD=1.5 PD=4 AS=3 PS=8
M224 O37 3 VDD VDD P L=0.54 W=3 AD=1.5 PD=4 AS=3 PS=8
M225 VDD 3 O37 VDD P L=0.54 W=3 AD=1.5 PD=4 AS=2.7 PS=7.8
M226 O38 3 VDD VDD P L=0.54 W=3 AD=2.7 PD=7.8 AS=1.5 PS=4
M227 VDD 3 O38 VDD P L=0.54 W=3 AD=1.5 PD=4 AS=3 PS=8
M228 O38 3 VDD VDD P L=0.54 W=3 AD=1.5 PD=4 AS=3 PS=8
M229 VDD 3 O38 VDD P L=0.54 W=3 AD=1.5 PD=4 AS=3 PS=8
M230 O38 3 VDD VDD P L=0.54 W=3 AD=1.5 PD=4 AS=3 PS=8
M231 VDD 3 O38 VDD P L=0.54 W=3 AD=1.5 PD=4 AS=2.7 PS=7.8
M232 O39 3 VDD VDD P L=0.54 W=3 AD=2.7 PD=7.8 AS=1.5 PS=4
M233 VDD 3 O39 VDD P L=0.54 W=3 AD=1.5 PD=4 AS=3 PS=8
M234 O39 3 VDD VDD P L=0.54 W=3 AD=1.5 PD=4 AS=3 PS=8
M235 VDD 3 O39 VDD P L=0.54 W=3 AD=1.5 PD=4 AS=3 PS=8
M236 O39 3 VDD VDD P L=0.54 W=3 AD=1.5 PD=4 AS=3 PS=8
M237 VDD 3 O39 VDD P L=0.54 W=3 AD=1.5 PD=4 AS=2.7 PS=7.8
M238 O40 3 VDD VDD P L=0.54 W=3 AD=2.7 PD=7.8 AS=1.5 PS=4
M239 VDD 3 O40 VDD P L=0.54 W=3 AD=1.5 PD=4 AS=3 PS=8
M240 O40 3 VDD VDD P L=0.54 W=3 AD=1.5 PD=4 AS=3 PS=8
M241 VDD 3 O40 VDD P L=0.54 W=3 AD=1.5 PD=4 AS=3 PS=8
M242 O40 3 VDD VDD P L=0.54 W=3 AD=1.5 PD=4 AS=3 PS=8
M243 VDD 3 O40 VDD P L=0.54 W=3 AD=1.5 PD=4 AS=2.7 PS=7.8
M244 O41 3 VDD VDD P L=0.54 W=3 AD=2.7 PD=7.8 AS=1.5 PS=4
M245 VDD 3 O41 VDD P L=0.54 W=3 AD=1.5 PD=4 AS=3 PS=8
M246 O41 3 VDD VDD P L=0.54 W=3 AD=1.5 PD=4 AS=3 PS=8
M247 VDD 3 O41 VDD P L=0.54 W=3 AD=1.5 PD=4 AS=3 PS=8
M248 O41 3 VDD VDD P L=0.54 W=3 AD=1.5 PD=4 AS=3 PS=8
M249 VDD 3 O41 VDD P L=0.54 W=3 AD=1.5 PD=4 AS=2.7 PS=7.8
M250 O42 3 VDD VDD P L=0.54 W=3 AD=2.7 PD=7.8 AS=1.5 PS=4
M251 VDD 3 O42 VDD P L=0.54 W=3 AD=1.5 PD=4 AS=3 PS=8
M252 O42 3 VDD VDD P L=0.54 W=3 AD=1.5 PD=4 AS=3 PS=8
M253 VDD 3 O42 VDD P L=0.54 W=3 AD=1.5 PD=4 AS=3 PS=8
M254 O42 3 VDD VDD P L=0.54 W=3 AD=1.5 PD=4 AS=3 PS=8
M255 VDD 3 O42 VDD P L=0.54 W=3 AD=1.5 PD=4 AS=2.7 PS=7.8
M256 O43 3 VDD VDD P L=0.54 W=3 AD=2.7 PD=7.8 AS=1.5 PS=4
M257 VDD 3 O43 VDD P L=0.54 W=3 AD=1.5 PD=4 AS=3 PS=8
M258 O43 3 VDD VDD P L=0.54 W=3 AD=1.5 PD=4 AS=3 PS=8
M259 VDD 3 O43 VDD P L=0.54 W=3 AD=1.5 PD=4 AS=3 PS=8
M260 O43 3 VDD VDD P L=0.54 W=3 AD=1.5 PD=4 AS=3 PS=8
M261 VDD 3 O43 VDD P L=0.54 W=3 AD=1.5 PD=4 AS=2.7 PS=7.8
M262 O44 3 VDD VDD P L=0.54 W=3 AD=2.7 PD=7.8 AS=1.5 PS=4
M263 VDD 3 O44 VDD P L=0.54 W=3 AD=1.5 PD=4 AS=3 PS=8
M264 O44 3 VDD VDD P L=0.54 W=3 AD=1.5 PD=4 AS=3 PS=8
M265 VDD 3 O44 VDD P L=0.54 W=3 AD=1.5 PD=4 AS=3 PS=8
M266 O44 3 VDD VDD P L=0.54 W=3 AD=1.5 PD=4 AS=3 PS=8
M267 VDD 3 O44 VDD P L=0.54 W=3 AD=1.5 PD=4 AS=2.7 PS=7.8
M268 O45 3 VDD VDD P L=0.54 W=3 AD=2.7 PD=7.8 AS=1.5 PS=4
M269 VDD 3 O45 VDD P L=0.54 W=3 AD=1.5 PD=4 AS=3 PS=8
M270 O45 3 VDD VDD P L=0.54 W=3 AD=1.5 PD=4 AS=3 PS=8
M271 VDD 3 O45 VDD P L=0.54 W=3 AD=1.5 PD=4 AS=3 PS=8
M272 O45 3 VDD VDD P L=0.54 W=3 AD=1.5 PD=4 AS=3 PS=8
M273 VDD 3 O45 VDD P L=0.54 W=3 AD=1.5 PD=4 AS=2.7 PS=7.8
M274 O46 3 VDD VDD P L=0.54 W=3 AD=2.7 PD=7.8 AS=1.5 PS=4
M275 VDD 3 O46 VDD P L=0.54 W=3 AD=1.5 PD=4 AS=3 PS=8
M276 O46 3 VDD VDD P L=0.54 W=3 AD=1.5 PD=4 AS=3 PS=8
M277 VDD 3 O46 VDD P L=0.54 W=3 AD=1.5 PD=4 AS=3 PS=8
M278 O46 3 VDD VDD P L=0.54 W=3 AD=1.5 PD=4 AS=3 PS=8
M279 VDD 3 O46 VDD P L=0.54 W=3 AD=1.5 PD=4 AS=2.7 PS=7.8
M280 O47 3 VDD VDD P L=0.54 W=3 AD=2.7 PD=7.8 AS=1.5 PS=4
M281 VDD 3 O47 VDD P L=0.54 W=3 AD=1.5 PD=4 AS=3 PS=8
M282 O47 3 VDD VDD P L=0.54 W=3 AD=1.5 PD=4 AS=3 PS=8
M283 VDD 3 O47 VDD P L=0.54 W=3 AD=1.5 PD=4 AS=3 PS=8
M284 O47 3 VDD VDD P L=0.54 W=3 AD=1.5 PD=4 AS=3 PS=8
M285 VDD 3 O47 VDD P L=0.54 W=3 AD=1.5 PD=4 AS=2.7 PS=7.8
M286 O48 3 VDD VDD P L=0.54 W=3 AD=2.7 PD=7.8 AS=1.5 PS=4
M287 VDD 3 O48 VDD P L=0.54 W=3 AD=1.5 PD=4 AS=3 PS=8
M288 O48 3 VDD VDD P L=0.54 W=3 AD=1.5 PD=4 AS=3 PS=8
M289 VDD 3 O48 VDD P L=0.54 W=3 AD=1.5 PD=4 AS=3 PS=8
M290 O48 3 VDD VDD P L=0.54 W=3 AD=1.5 PD=4 AS=3 PS=8
M291 VDD 3 O48 VDD P L=0.54 W=3 AD=1.5 PD=4 AS=2.7 PS=7.8
M292 O49 3 VDD VDD P L=0.54 W=3 AD=2.7 PD=7.8 AS=1.5 PS=4
M293 VDD 3 O49 VDD P L=0.54 W=3 AD=1.5 PD=4 AS=3 PS=8
M294 O49 3 VDD VDD P L=0.54 W=3 AD=1.5 PD=4 AS=3 PS=8
M295 VDD 3 O49 VDD P L=0.54 W=3 AD=1.5 PD=4 AS=3 PS=8
M296 O49 3 VDD VDD P L=0.54 W=3 AD=1.5 PD=4 AS=3 PS=8
M297 VDD 3 O49 VDD P L=0.54 W=3 AD=1.5 PD=4 AS=2.7 PS=7.8
M298 O50 3 VDD VDD P L=0.54 W=3 AD=2.7 PD=7.8 AS=1.5 PS=4
M299 VDD 3 O50 VDD P L=0.54 W=3 AD=1.5 PD=4 AS=3 PS=8
M300 O50 3 VDD VDD P L=0.54 W=3 AD=1.5 PD=4 AS=3 PS=8
M301 VDD 3 O50 VDD P L=0.54 W=3 AD=1.5 PD=4 AS=3 PS=8
M302 O50 3 VDD VDD P L=0.54 W=3 AD=1.5 PD=4 AS=3 PS=8
M303 VDD 3 O50 VDD P L=0.54 W=3 AD=1.5 PD=4 AS=2.7 PS=7.8
M304 O51 3 VDD VDD P L=0.54 W=3 AD=2.7 PD=7.8 AS=1.5 PS=4
M305 VDD 3 O51 VDD P L=0.54 W=3 AD=1.5 PD=4 AS=3 PS=8
M306 O51 3 VDD VDD P L=0.54 W=3 AD=1.5 PD=4 AS=3 PS=8
M307 VDD 3 O51 VDD P L=0.54 W=3 AD=1.5 PD=4 AS=3 PS=8
M308 O51 3 VDD VDD P L=0.54 W=3 AD=1.5 PD=4 AS=3 PS=8
M309 VDD 3 O51 VDD P L=0.54 W=3 AD=1.5 PD=4 AS=2.7 PS=7.8
M310 O52 3 VDD VDD P L=0.54 W=3 AD=2.7 PD=7.8 AS=1.5 PS=4
M311 VDD 3 O52 VDD P L=0.54 W=3 AD=1.5 PD=4 AS=3 PS=8
M312 O52 3 VDD VDD P L=0.54 W=3 AD=1.5 PD=4 AS=3 PS=8
M313 VDD 3 O52 VDD P L=0.54 W=3 AD=1.5 PD=4 AS=3 PS=8
M314 O52 3 VDD VDD P L=0.54 W=3 AD=1.5 PD=4 AS=3 PS=8
M315 VDD 3 O52 VDD P L=0.54 W=3 AD=1.5 PD=4 AS=2.7 PS=7.8
M316 O53 3 VDD VDD P L=0.54 W=3 AD=2.7 PD=7.8 AS=1.5 PS=4
M317 VDD 3 O53 VDD P L=0.54 W=3 AD=1.5 PD=4 AS=3 PS=8
M318 O53 3 VDD VDD P L=0.54 W=3 AD=1.5 PD=4 AS=3 PS=8
M319 VDD 3 O53 VDD P L=0.54 W=3 AD=1.5 PD=4 AS=3 PS=8
M320 O53 3 VDD VDD P L=0.54 W=3 AD=1.5 PD=4 AS=3 PS=8
M321 VDD 3 O53 VDD P L=0.54 W=3 AD=1.5 PD=4 AS=2.7 PS=7.8
M322 O54 3 VDD VDD P L=0.54 W=3 AD=2.7 PD=7.8 AS=1.5 PS=4
M323 VDD 3 O54 VDD P L=0.54 W=3 AD=1.5 PD=4 AS=3 PS=8
M324 O54 3 VDD VDD P L=0.54 W=3 AD=1.5 PD=4 AS=3 PS=8
M325 VDD 3 O54 VDD P L=0.54 W=3 AD=1.5 PD=4 AS=3 PS=8
M326 O54 3 VDD VDD P L=0.54 W=3 AD=1.5 PD=4 AS=3 PS=8
M327 VDD 3 O54 VDD P L=0.54 W=3 AD=1.5 PD=4 AS=2.7 PS=7.8
M328 O55 3 VDD VDD P L=0.54 W=3 AD=2.7 PD=7.8 AS=1.5 PS=4
M329 VDD 3 O55 VDD P L=0.54 W=3 AD=1.5 PD=4 AS=3 PS=8
M330 O55 3 VDD VDD P L=0.54 W=3 AD=1.5 PD=4 AS=3 PS=8
M331 VDD 3 O55 VDD P L=0.54 W=3 AD=1.5 PD=4 AS=3 PS=8
M332 O55 3 VDD VDD P L=0.54 W=3 AD=1.5 PD=4 AS=3 PS=8
M333 VDD 3 O55 VDD P L=0.54 W=3 AD=1.5 PD=4 AS=2.7 PS=7.8
M334 O56 3 VDD VDD P L=0.54 W=3 AD=2.7 PD=7.8 AS=1.5 PS=4
M335 VDD 3 O56 VDD P L=0.54 W=3 AD=1.5 PD=4 AS=3 PS=8
M336 O56 3 VDD VDD P L=0.54 W=3 AD=1.5 PD=4 AS=3 PS=8
M337 VDD 3 O56 VDD P L=0.54 W=3 AD=1.5 PD=4 AS=3 PS=8
M338 O56 3 VDD VDD P L=0.54 W=3 AD=1.5 PD=4 AS=3 PS=8
M339 VDD 3 O56 VDD P L=0.54 W=3 AD=1.5 PD=4 AS=2.7 PS=7.8
M340 O57 3 VDD VDD P L=0.54 W=3 AD=2.7 PD=7.8 AS=1.5 PS=4
M341 VDD 3 O57 VDD P L=0.54 W=3 AD=1.5 PD=4 AS=3 PS=8
M342 O57 3 VDD VDD P L=0.54 W=3 AD=1.5 PD=4 AS=3 PS=8
M343 VDD 3 O57 VDD P L=0.54 W=3 AD=1.5 PD=4 AS=3 PS=8
M344 O57 3 VDD VDD P L=0.54 W=3 AD=1.5 PD=4 AS=3 PS=8
M345 VDD 3 O57 VDD P L=0.54 W=3 AD=1.5 PD=4 AS=2.7 PS=7.8
M346 O58 3 VDD VDD P L=0.54 W=3 AD=2.7 PD=7.8 AS=1.5 PS=4
M347 VDD 3 O58 VDD P L=0.54 W=3 AD=1.5 PD=4 AS=3 PS=8
M348 O58 3 VDD VDD P L=0.54 W=3 AD=1.5 PD=4 AS=3 PS=8
M349 VDD 3 O58 VDD P L=0.54 W=3 AD=1.5 PD=4 AS=3 PS=8
M350 O58 3 VDD VDD P L=0.54 W=3 AD=1.5 PD=4 AS=3 PS=8
M351 VDD 3 O58 VDD P L=0.54 W=3 AD=1.5 PD=4 AS=2.7 PS=7.8
M352 O59 3 VDD VDD P L=0.54 W=3 AD=2.7 PD=7.8 AS=1.5 PS=4
M353 VDD 3 O59 VDD P L=0.54 W=3 AD=1.5 PD=4 AS=3 PS=8
M354 O59 3 VDD VDD P L=0.54 W=3 AD=1.5 PD=4 AS=3 PS=8
M355 VDD 3 O59 VDD P L=0.54 W=3 AD=1.5 PD=4 AS=3 PS=8
M356 O59 3 VDD VDD P L=0.54 W=3 AD=1.5 PD=4 AS=3 PS=8
M357 VDD 3 O59 VDD P L=0.54 W=3 AD=1.5 PD=4 AS=2.7 PS=7.8
M358 O60 3 VDD VDD P L=0.54 W=3 AD=2.7 PD=7.8 AS=1.5 PS=4
M359 VDD 3 O60 VDD P L=0.54 W=3 AD=1.5 PD=4 AS=3 PS=8
M360 O60 3 VDD VDD P L=0.54 W=3 AD=1.5 PD=4 AS=3 PS=8
M361 VDD 3 O60 VDD P L=0.54 W=3 AD=1.5 PD=4 AS=3 PS=8
M362 O60 3 VDD VDD P L=0.54 W=3 AD=1.5 PD=4 AS=3 PS=8
M363 VDD 3 O60 VDD P L=0.54 W=3 AD=1.5 PD=4 AS=2.7 PS=7.8
M364 O61 3 VDD VDD P L=0.54 W=3 AD=2.7 PD=7.8 AS=1.5 PS=4
M365 VDD 3 O61 VDD P L=0.54 W=3 AD=1.5 PD=4 AS=3 PS=8
M366 O61 3 VDD VDD P L=0.54 W=3 AD=1.5 PD=4 AS=3 PS=8
M367 VDD 3 O61 VDD P L=0.54 W=3 AD=1.5 PD=4 AS=3 PS=8
M368 O61 3 VDD VDD P L=0.54 W=3 AD=1.5 PD=4 AS=3 PS=8
M369 VDD 3 O61 VDD P L=0.54 W=3 AD=1.5 PD=4 AS=2.7 PS=7.8
M370 O62 3 VDD VDD P L=0.54 W=3 AD=2.7 PD=7.8 AS=1.5 PS=4
M371 VDD 3 O62 VDD P L=0.54 W=3 AD=1.5 PD=4 AS=3 PS=8
M372 O62 3 VDD VDD P L=0.54 W=3 AD=1.5 PD=4 AS=3 PS=8
M373 VDD 3 O62 VDD P L=0.54 W=3 AD=1.5 PD=4 AS=3 PS=8
M374 O62 3 VDD VDD P L=0.54 W=3 AD=1.5 PD=4 AS=3 PS=8
M375 VDD 3 O62 VDD P L=0.54 W=3 AD=1.5 PD=4 AS=2.7 PS=7.8
M376 O63 3 VDD VDD P L=0.54 W=3 AD=2.7 PD=7.8 AS=1.5 PS=4
M377 VDD 3 O63 VDD P L=0.54 W=3 AD=1.5 PD=4 AS=3 PS=8
M378 O63 3 VDD VDD P L=0.54 W=3 AD=1.5 PD=4 AS=3 PS=8
M379 VDD 3 O63 VDD P L=0.54 W=3 AD=1.5 PD=4 AS=3 PS=8
M380 O63 3 VDD VDD P L=0.54 W=3 AD=1.5 PD=4 AS=3 PS=8
M381 VDD 3 O63 VDD P L=0.54 W=3 AD=1.5 PD=4 AS=2.7 PS=7.8
M382 O64 3 VDD VDD P L=0.54 W=3 AD=2.7 PD=7.8 AS=1.5 PS=4
M383 VDD 3 O64 VDD P L=0.54 W=3 AD=1.5 PD=4 AS=3 PS=8
M384 O64 3 VDD VDD P L=0.54 W=3 AD=1.5 PD=4 AS=3 PS=8
M385 VDD 3 O64 VDD P L=0.54 W=3 AD=1.5 PD=4 AS=3 PS=8
M386 O64 3 VDD VDD P L=0.54 W=3 AD=1.5 PD=4 AS=3 PS=8
M387 VDD 3 O64 VDD P L=0.54 W=3 AD=1.5 PD=4 AS=2.7 PS=7.8
M388 O65 3 VDD VDD P L=0.54 W=3 AD=2.7 PD=7.8 AS=1.5 PS=4
M389 VDD 3 O65 VDD P L=0.54 W=3 AD=1.5 PD=4 AS=3 PS=8
M390 O65 3 VDD VDD P L=0.54 W=3 AD=1.5 PD=4 AS=3 PS=8
M391 VDD 3 O65 VDD P L=0.54 W=3 AD=1.5 PD=4 AS=3 PS=8
M392 O65 3 VDD VDD P L=0.54 W=3 AD=1.5 PD=4 AS=3 PS=8
M393 VDD 3 O65 VDD P L=0.54 W=3 AD=1.5 PD=4 AS=2.7 PS=7.8
M394 O66 3 VDD VDD P L=0.54 W=3 AD=2.7 PD=7.8 AS=1.5 PS=4
M395 VDD 3 O66 VDD P L=0.54 W=3 AD=1.5 PD=4 AS=3 PS=8
M396 O66 3 VDD VDD P L=0.54 W=3 AD=1.5 PD=4 AS=3 PS=8
M397 VDD 3 O66 VDD P L=0.54 W=3 AD=1.5 PD=4 AS=3 PS=8
M398 O66 3 VDD VDD P L=0.54 W=3 AD=1.5 PD=4 AS=3 PS=8
M399 VDD 3 O66 VDD P L=0.54 W=3 AD=1.5 PD=4 AS=2.7 PS=7.8
M400 O67 3 VDD VDD P L=0.54 W=3 AD=2.7 PD=7.8 AS=1.5 PS=4
M401 VDD 3 O67 VDD P L=0.54 W=3 AD=1.5 PD=4 AS=3 PS=8
M402 O67 3 VDD VDD P L=0.54 W=3 AD=1.5 PD=4 AS=3 PS=8
M403 VDD 3 O67 VDD P L=0.54 W=3 AD=1.5 PD=4 AS=3 PS=8
M404 O67 3 VDD VDD P L=0.54 W=3 AD=1.5 PD=4 AS=3 PS=8
M405 VDD 3 O67 VDD P L=0.54 W=3 AD=1.5 PD=4 AS=2.7 PS=7.8
M406 O68 3 VDD VDD P L=0.54 W=3 AD=2.7 PD=7.8 AS=1.5 PS=4
M407 VDD 3 O68 VDD P L=0.54 W=3 AD=1.5 PD=4 AS=3 PS=8
M408 O68 3 VDD VDD P L=0.54 W=3 AD=1.5 PD=4 AS=3 PS=8
M409 VDD 3 O68 VDD P L=0.54 W=3 AD=1.5 PD=4 AS=3 PS=8
M410 O68 3 VDD VDD P L=0.54 W=3 AD=1.5 PD=4 AS=3 PS=8
M411 VDD 3 O68 VDD P L=0.54 W=3 AD=1.5 PD=4 AS=2.7 PS=7.8
M412 O69 3 VDD VDD P L=0.54 W=3 AD=2.7 PD=7.8 AS=1.5 PS=4
M413 VDD 3 O69 VDD P L=0.54 W=3 AD=1.5 PD=4 AS=3 PS=8
M414 O69 3 VDD VDD P L=0.54 W=3 AD=1.5 PD=4 AS=3 PS=8
M415 VDD 3 O69 VDD P L=0.54 W=3 AD=1.5 PD=4 AS=3 PS=8
M416 O69 3 VDD VDD P L=0.54 W=3 AD=1.5 PD=4 AS=3 PS=8
M417 VDD 3 O69 VDD P L=0.54 W=3 AD=1.5 PD=4 AS=2.7 PS=7.8
M418 O1 3 GND GND N L=0.54 W=1.5 AD=1.35 PD=4.8 AS=0.75 PS=2.5
M419 GND 3 O1 GND N L=0.54 W=1.5 AD=0.75 PD=2.5 AS=1.5 PS=5
M420 O1 3 GND GND N L=0.54 W=1.5 AD=0.75 PD=2.5 AS=1.5 PS=5
M421 GND 3 O1 GND N L=0.54 W=1.5 AD=0.75 PD=2.5 AS=1.5 PS=5
M422 O1 3 GND GND N L=0.54 W=1.5 AD=0.75 PD=2.5 AS=1.5 PS=5
M423 GND 3 O1 GND N L=0.54 W=1.5 AD=0.75 PD=2.5 AS=1.35 PS=4.8
M424 O2 3 GND GND N L=0.54 W=1.5 AD=1.35 PD=4.8 AS=0.75 PS=2.5
M425 GND 3 O2 GND N L=0.54 W=1.5 AD=0.75 PD=2.5 AS=1.5 PS=5
M426 O2 3 GND GND N L=0.54 W=1.5 AD=0.75 PD=2.5 AS=1.5 PS=5
M427 GND 3 O2 GND N L=0.54 W=1.5 AD=0.75 PD=2.5 AS=1.5 PS=5
M428 O2 3 GND GND N L=0.54 W=1.5 AD=0.75 PD=2.5 AS=1.5 PS=5
M429 GND 3 O2 GND N L=0.54 W=1.5 AD=0.75 PD=2.5 AS=1.35 PS=4.8
M430 O3 3 GND GND N L=0.54 W=1.5 AD=1.35 PD=4.8 AS=0.75 PS=2.5
M431 GND 3 O3 GND N L=0.54 W=1.5 AD=0.75 PD=2.5 AS=1.5 PS=5
M432 O3 3 GND GND N L=0.54 W=1.5 AD=0.75 PD=2.5 AS=1.5 PS=5
M433 GND 3 O3 GND N L=0.54 W=1.5 AD=0.75 PD=2.5 AS=1.5 PS=5
M434 O3 3 GND GND N L=0.54 W=1.5 AD=0.75 PD=2.5 AS=1.5 PS=5
M435 GND 3 O3 GND N L=0.54 W=1.5 AD=0.75 PD=2.5 AS=1.35 PS=4.8
M436 O4 3 GND GND N L=0.54 W=1.5 AD=1.35 PD=4.8 AS=0.75 PS=2.5
M437 GND 3 O4 GND N L=0.54 W=1.5 AD=0.75 PD=2.5 AS=1.5 PS=5
M438 O4 3 GND GND N L=0.54 W=1.5 AD=0.75 PD=2.5 AS=1.5 PS=5
M439 GND 3 O4 GND N L=0.54 W=1.5 AD=0.75 PD=2.5 AS=1.5 PS=5
M440 O4 3 GND GND N L=0.54 W=1.5 AD=0.75 PD=2.5 AS=1.5 PS=5
M441 GND 3 O4 GND N L=0.54 W=1.5 AD=0.75 PD=2.5 AS=1.35 PS=4.8
M442 O5 3 GND GND N L=0.54 W=1.5 AD=1.35 PD=4.8 AS=0.75 PS=2.5
M443 GND 3 O5 GND N L=0.54 W=1.5 AD=0.75 PD=2.5 AS=1.5 PS=5
M444 O5 3 GND GND N L=0.54 W=1.5 AD=0.75 PD=2.5 AS=1.5 PS=5
M445 GND 3 O5 GND N L=0.54 W=1.5 AD=0.75 PD=2.5 AS=1.5 PS=5
M446 O5 3 GND GND N L=0.54 W=1.5 AD=0.75 PD=2.5 AS=1.5 PS=5
M447 GND 3 O5 GND N L=0.54 W=1.5 AD=0.75 PD=2.5 AS=1.35 PS=4.8
M448 3 IN1 GND GND N L=0.54 W=1.5 AD=1.17 PD=4.8 AS=0.75 PS=2.5
M449 GND IN1 3 GND N L=0.54 W=1.5 AD=0.75 PD=2.5 AS=1.5 PS=5
M450 3 IN1 GND GND N L=0.54 W=1.5 AD=0.75 PD=2.5 AS=1.5 PS=5
M451 GND IN1 3 GND N L=0.54 W=1.5 AD=0.75 PD=2.5 AS=1.17 PS=4.8
M452 O6 3 GND GND N L=0.54 W=1.5 AD=1.35 PD=4.8 AS=0.75 PS=2.5
M453 GND 3 O6 GND N L=0.54 W=1.5 AD=0.75 PD=2.5 AS=1.5 PS=5
M454 O6 3 GND GND N L=0.54 W=1.5 AD=0.75 PD=2.5 AS=1.5 PS=5
M455 GND 3 O6 GND N L=0.54 W=1.5 AD=0.75 PD=2.5 AS=1.5 PS=5
M456 O6 3 GND GND N L=0.54 W=1.5 AD=0.75 PD=2.5 AS=1.5 PS=5
M457 GND 3 O6 GND N L=0.54 W=1.5 AD=0.75 PD=2.5 AS=1.35 PS=4.8
M458 O7 3 GND GND N L=0.54 W=1.5 AD=1.35 PD=4.8 AS=0.75 PS=2.5
M459 GND 3 O7 GND N L=0.54 W=1.5 AD=0.75 PD=2.5 AS=1.5 PS=5
M460 O7 3 GND GND N L=0.54 W=1.5 AD=0.75 PD=2.5 AS=1.5 PS=5
M461 GND 3 O7 GND N L=0.54 W=1.5 AD=0.75 PD=2.5 AS=1.5 PS=5
M462 O7 3 GND GND N L=0.54 W=1.5 AD=0.75 PD=2.5 AS=1.5 PS=5
M463 GND 3 O7 GND N L=0.54 W=1.5 AD=0.75 PD=2.5 AS=1.35 PS=4.8
M464 O8 3 GND GND N L=0.54 W=1.5 AD=1.35 PD=4.8 AS=0.75 PS=2.5
M465 GND 3 O8 GND N L=0.54 W=1.5 AD=0.75 PD=2.5 AS=1.5 PS=5
M466 O8 3 GND GND N L=0.54 W=1.5 AD=0.75 PD=2.5 AS=1.5 PS=5
M467 GND 3 O8 GND N L=0.54 W=1.5 AD=0.75 PD=2.5 AS=1.5 PS=5
M468 O8 3 GND GND N L=0.54 W=1.5 AD=0.75 PD=2.5 AS=1.5 PS=5
M469 GND 3 O8 GND N L=0.54 W=1.5 AD=0.75 PD=2.5 AS=1.35 PS=4.8
M470 O9 3 GND GND N L=0.54 W=1.5 AD=1.35 PD=4.8 AS=0.75 PS=2.5
M471 GND 3 O9 GND N L=0.54 W=1.5 AD=0.75 PD=2.5 AS=1.5 PS=5
M472 O9 3 GND GND N L=0.54 W=1.5 AD=0.75 PD=2.5 AS=1.5 PS=5
M473 GND 3 O9 GND N L=0.54 W=1.5 AD=0.75 PD=2.5 AS=1.5 PS=5
M474 O9 3 GND GND N L=0.54 W=1.5 AD=0.75 PD=2.5 AS=1.5 PS=5
M475 GND 3 O9 GND N L=0.54 W=1.5 AD=0.75 PD=2.5 AS=1.35 PS=4.8
M476 O10 3 GND GND N L=0.54 W=1.5 AD=1.35 PD=4.8 AS=0.75 PS=2.5
M477 GND 3 O10 GND N L=0.54 W=1.5 AD=0.75 PD=2.5 AS=1.5 PS=5
M478 O10 3 GND GND N L=0.54 W=1.5 AD=0.75 PD=2.5 AS=1.5 PS=5
M479 GND 3 O10 GND N L=0.54 W=1.5 AD=0.75 PD=2.5 AS=1.5 PS=5
M480 O10 3 GND GND N L=0.54 W=1.5 AD=0.75 PD=2.5 AS=1.5 PS=5
M481 GND 3 O10 GND N L=0.54 W=1.5 AD=0.75 PD=2.5 AS=1.35 PS=4.8
M482 O11 3 GND GND N L=0.54 W=1.5 AD=1.35 PD=4.8 AS=0.75 PS=2.5
M483 GND 3 O11 GND N L=0.54 W=1.5 AD=0.75 PD=2.5 AS=1.5 PS=5
M484 O11 3 GND GND N L=0.54 W=1.5 AD=0.75 PD=2.5 AS=1.5 PS=5
M485 GND 3 O11 GND N L=0.54 W=1.5 AD=0.75 PD=2.5 AS=1.5 PS=5
M486 O11 3 GND GND N L=0.54 W=1.5 AD=0.75 PD=2.5 AS=1.5 PS=5
M487 GND 3 O11 GND N L=0.54 W=1.5 AD=0.75 PD=2.5 AS=1.35 PS=4.8
M488 O12 3 GND GND N L=0.54 W=1.5 AD=1.35 PD=4.8 AS=0.75 PS=2.5
M489 GND 3 O12 GND N L=0.54 W=1.5 AD=0.75 PD=2.5 AS=1.5 PS=5
M490 O12 3 GND GND N L=0.54 W=1.5 AD=0.75 PD=2.5 AS=1.5 PS=5
M491 GND 3 O12 GND N L=0.54 W=1.5 AD=0.75 PD=2.5 AS=1.5 PS=5
M492 O12 3 GND GND N L=0.54 W=1.5 AD=0.75 PD=2.5 AS=1.5 PS=5
M493 GND 3 O12 GND N L=0.54 W=1.5 AD=0.75 PD=2.5 AS=1.35 PS=4.8
M494 O13 3 GND GND N L=0.54 W=1.5 AD=1.35 PD=4.8 AS=0.75 PS=2.5
M495 GND 3 O13 GND N L=0.54 W=1.5 AD=0.75 PD=2.5 AS=1.5 PS=5
M496 O13 3 GND GND N L=0.54 W=1.5 AD=0.75 PD=2.5 AS=1.5 PS=5
M497 GND 3 O13 GND N L=0.54 W=1.5 AD=0.75 PD=2.5 AS=1.5 PS=5
M498 O13 3 GND GND N L=0.54 W=1.5 AD=0.75 PD=2.5 AS=1.5 PS=5
M499 GND 3 O13 GND N L=0.54 W=1.5 AD=0.75 PD=2.5 AS=1.35 PS=4.8
M500 O14 3 GND GND N L=0.54 W=1.5 AD=1.35 PD=4.8 AS=0.75 PS=2.5
M501 GND 3 O14 GND N L=0.54 W=1.5 AD=0.75 PD=2.5 AS=1.5 PS=5
M502 O14 3 GND GND N L=0.54 W=1.5 AD=0.75 PD=2.5 AS=1.5 PS=5
M503 GND 3 O14 GND N L=0.54 W=1.5 AD=0.75 PD=2.5 AS=1.5 PS=5
M504 O14 3 GND GND N L=0.54 W=1.5 AD=0.75 PD=2.5 AS=1.5 PS=5
M505 GND 3 O14 GND N L=0.54 W=1.5 AD=0.75 PD=2.5 AS=1.35 PS=4.8
M506 O15 3 GND GND N L=0.54 W=1.5 AD=1.35 PD=4.8 AS=0.75 PS=2.5
M507 GND 3 O15 GND N L=0.54 W=1.5 AD=0.75 PD=2.5 AS=1.5 PS=5
M508 O15 3 GND GND N L=0.54 W=1.5 AD=0.75 PD=2.5 AS=1.5 PS=5
M509 GND 3 O15 GND N L=0.54 W=1.5 AD=0.75 PD=2.5 AS=1.5 PS=5
M510 O15 3 GND GND N L=0.54 W=1.5 AD=0.75 PD=2.5 AS=1.5 PS=5
M511 GND 3 O15 GND N L=0.54 W=1.5 AD=0.75 PD=2.5 AS=1.35 PS=4.8
M512 O16 3 GND GND N L=0.54 W=1.5 AD=1.35 PD=4.8 AS=0.75 PS=2.5
M513 GND 3 O16 GND N L=0.54 W=1.5 AD=0.75 PD=2.5 AS=1.5 PS=5
M514 O16 3 GND GND N L=0.54 W=1.5 AD=0.75 PD=2.5 AS=1.5 PS=5
M515 GND 3 O16 GND N L=0.54 W=1.5 AD=0.75 PD=2.5 AS=1.5 PS=5
M516 O16 3 GND GND N L=0.54 W=1.5 AD=0.75 PD=2.5 AS=1.5 PS=5
M517 GND 3 O16 GND N L=0.54 W=1.5 AD=0.75 PD=2.5 AS=1.35 PS=4.8
M518 O17 3 GND GND N L=0.54 W=1.5 AD=1.35 PD=4.8 AS=0.75 PS=2.5
M519 GND 3 O17 GND N L=0.54 W=1.5 AD=0.75 PD=2.5 AS=1.5 PS=5
M520 O17 3 GND GND N L=0.54 W=1.5 AD=0.75 PD=2.5 AS=1.5 PS=5
M521 GND 3 O17 GND N L=0.54 W=1.5 AD=0.75 PD=2.5 AS=1.5 PS=5
M522 O17 3 GND GND N L=0.54 W=1.5 AD=0.75 PD=2.5 AS=1.5 PS=5
M523 GND 3 O17 GND N L=0.54 W=1.5 AD=0.75 PD=2.5 AS=1.35 PS=4.8
M524 O18 3 GND GND N L=0.54 W=1.5 AD=1.35 PD=4.8 AS=0.75 PS=2.5
M525 GND 3 O18 GND N L=0.54 W=1.5 AD=0.75 PD=2.5 AS=1.5 PS=5
M526 O18 3 GND GND N L=0.54 W=1.5 AD=0.75 PD=2.5 AS=1.5 PS=5
M527 GND 3 O18 GND N L=0.54 W=1.5 AD=0.75 PD=2.5 AS=1.5 PS=5
M528 O18 3 GND GND N L=0.54 W=1.5 AD=0.75 PD=2.5 AS=1.5 PS=5
M529 GND 3 O18 GND N L=0.54 W=1.5 AD=0.75 PD=2.5 AS=1.35 PS=4.8
M530 O19 3 GND GND N L=0.54 W=1.5 AD=1.35 PD=4.8 AS=0.75 PS=2.5
M531 GND 3 O19 GND N L=0.54 W=1.5 AD=0.75 PD=2.5 AS=1.5 PS=5
M532 O19 3 GND GND N L=0.54 W=1.5 AD=0.75 PD=2.5 AS=1.5 PS=5
M533 GND 3 O19 GND N L=0.54 W=1.5 AD=0.75 PD=2.5 AS=1.5 PS=5
M534 O19 3 GND GND N L=0.54 W=1.5 AD=0.75 PD=2.5 AS=1.5 PS=5
M535 GND 3 O19 GND N L=0.54 W=1.5 AD=0.75 PD=2.5 AS=1.35 PS=4.8
M536 O20 3 GND GND N L=0.54 W=1.5 AD=1.35 PD=4.8 AS=0.75 PS=2.5
M537 GND 3 O20 GND N L=0.54 W=1.5 AD=0.75 PD=2.5 AS=1.5 PS=5
M538 O20 3 GND GND N L=0.54 W=1.5 AD=0.75 PD=2.5 AS=1.5 PS=5
M539 GND 3 O20 GND N L=0.54 W=1.5 AD=0.75 PD=2.5 AS=1.5 PS=5
M540 O20 3 GND GND N L=0.54 W=1.5 AD=0.75 PD=2.5 AS=1.5 PS=5
M541 GND 3 O20 GND N L=0.54 W=1.5 AD=0.75 PD=2.5 AS=1.35 PS=4.8
M542 O21 3 GND GND N L=0.54 W=1.5 AD=1.35 PD=4.8 AS=0.75 PS=2.5
M543 GND 3 O21 GND N L=0.54 W=1.5 AD=0.75 PD=2.5 AS=1.5 PS=5
M544 O21 3 GND GND N L=0.54 W=1.5 AD=0.75 PD=2.5 AS=1.5 PS=5
M545 GND 3 O21 GND N L=0.54 W=1.5 AD=0.75 PD=2.5 AS=1.5 PS=5
M546 O21 3 GND GND N L=0.54 W=1.5 AD=0.75 PD=2.5 AS=1.5 PS=5
M547 GND 3 O21 GND N L=0.54 W=1.5 AD=0.75 PD=2.5 AS=1.35 PS=4.8
M548 O22 3 GND GND N L=0.54 W=1.5 AD=1.35 PD=4.8 AS=0.75 PS=2.5
M549 GND 3 O22 GND N L=0.54 W=1.5 AD=0.75 PD=2.5 AS=1.5 PS=5
M550 O22 3 GND GND N L=0.54 W=1.5 AD=0.75 PD=2.5 AS=1.5 PS=5
M551 GND 3 O22 GND N L=0.54 W=1.5 AD=0.75 PD=2.5 AS=1.5 PS=5
M552 O22 3 GND GND N L=0.54 W=1.5 AD=0.75 PD=2.5 AS=1.5 PS=5
M553 GND 3 O22 GND N L=0.54 W=1.5 AD=0.75 PD=2.5 AS=1.35 PS=4.8
M554 O23 3 GND GND N L=0.54 W=1.5 AD=1.35 PD=4.8 AS=0.75 PS=2.5
M555 GND 3 O23 GND N L=0.54 W=1.5 AD=0.75 PD=2.5 AS=1.5 PS=5
M556 O23 3 GND GND N L=0.54 W=1.5 AD=0.75 PD=2.5 AS=1.5 PS=5
M557 GND 3 O23 GND N L=0.54 W=1.5 AD=0.75 PD=2.5 AS=1.5 PS=5
M558 O23 3 GND GND N L=0.54 W=1.5 AD=0.75 PD=2.5 AS=1.5 PS=5
M559 GND 3 O23 GND N L=0.54 W=1.5 AD=0.75 PD=2.5 AS=1.35 PS=4.8
M560 O24 3 GND GND N L=0.54 W=1.5 AD=1.35 PD=4.8 AS=0.75 PS=2.5
M561 GND 3 O24 GND N L=0.54 W=1.5 AD=0.75 PD=2.5 AS=1.5 PS=5
M562 O24 3 GND GND N L=0.54 W=1.5 AD=0.75 PD=2.5 AS=1.5 PS=5
M563 GND 3 O24 GND N L=0.54 W=1.5 AD=0.75 PD=2.5 AS=1.5 PS=5
M564 O24 3 GND GND N L=0.54 W=1.5 AD=0.75 PD=2.5 AS=1.5 PS=5
M565 GND 3 O24 GND N L=0.54 W=1.5 AD=0.75 PD=2.5 AS=1.35 PS=4.8
M566 O25 3 GND GND N L=0.54 W=1.5 AD=1.35 PD=4.8 AS=0.75 PS=2.5
M567 GND 3 O25 GND N L=0.54 W=1.5 AD=0.75 PD=2.5 AS=1.5 PS=5
M568 O25 3 GND GND N L=0.54 W=1.5 AD=0.75 PD=2.5 AS=1.5 PS=5
M569 GND 3 O25 GND N L=0.54 W=1.5 AD=0.75 PD=2.5 AS=1.5 PS=5
M570 O25 3 GND GND N L=0.54 W=1.5 AD=0.75 PD=2.5 AS=1.5 PS=5
M571 GND 3 O25 GND N L=0.54 W=1.5 AD=0.75 PD=2.5 AS=1.35 PS=4.8
M572 O26 3 GND GND N L=0.54 W=1.5 AD=1.35 PD=4.8 AS=0.75 PS=2.5
M573 GND 3 O26 GND N L=0.54 W=1.5 AD=0.75 PD=2.5 AS=1.5 PS=5
M574 O26 3 GND GND N L=0.54 W=1.5 AD=0.75 PD=2.5 AS=1.5 PS=5
M575 GND 3 O26 GND N L=0.54 W=1.5 AD=0.75 PD=2.5 AS=1.5 PS=5
M576 O26 3 GND GND N L=0.54 W=1.5 AD=0.75 PD=2.5 AS=1.5 PS=5
M577 GND 3 O26 GND N L=0.54 W=1.5 AD=0.75 PD=2.5 AS=1.35 PS=4.8
M578 O27 3 GND GND N L=0.54 W=1.5 AD=1.35 PD=4.8 AS=0.75 PS=2.5
M579 GND 3 O27 GND N L=0.54 W=1.5 AD=0.75 PD=2.5 AS=1.5 PS=5
M580 O27 3 GND GND N L=0.54 W=1.5 AD=0.75 PD=2.5 AS=1.5 PS=5
M581 GND 3 O27 GND N L=0.54 W=1.5 AD=0.75 PD=2.5 AS=1.5 PS=5
M582 O27 3 GND GND N L=0.54 W=1.5 AD=0.75 PD=2.5 AS=1.5 PS=5
M583 GND 3 O27 GND N L=0.54 W=1.5 AD=0.75 PD=2.5 AS=1.35 PS=4.8
M584 O28 3 GND GND N L=0.54 W=1.5 AD=1.35 PD=4.8 AS=0.75 PS=2.5
M585 GND 3 O28 GND N L=0.54 W=1.5 AD=0.75 PD=2.5 AS=1.5 PS=5
M586 O28 3 GND GND N L=0.54 W=1.5 AD=0.75 PD=2.5 AS=1.5 PS=5
M587 GND 3 O28 GND N L=0.54 W=1.5 AD=0.75 PD=2.5 AS=1.5 PS=5
M588 O28 3 GND GND N L=0.54 W=1.5 AD=0.75 PD=2.5 AS=1.5 PS=5
M589 GND 3 O28 GND N L=0.54 W=1.5 AD=0.75 PD=2.5 AS=1.35 PS=4.8
M590 O29 3 GND GND N L=0.54 W=1.5 AD=1.35 PD=4.8 AS=0.75 PS=2.5
M591 GND 3 O29 GND N L=0.54 W=1.5 AD=0.75 PD=2.5 AS=1.5 PS=5
M592 O29 3 GND GND N L=0.54 W=1.5 AD=0.75 PD=2.5 AS=1.5 PS=5
M593 GND 3 O29 GND N L=0.54 W=1.5 AD=0.75 PD=2.5 AS=1.5 PS=5
M594 O29 3 GND GND N L=0.54 W=1.5 AD=0.75 PD=2.5 AS=1.5 PS=5
M595 GND 3 O29 GND N L=0.54 W=1.5 AD=0.75 PD=2.5 AS=1.35 PS=4.8
M596 O30 3 GND GND N L=0.54 W=1.5 AD=1.35 PD=4.8 AS=0.75 PS=2.5
M597 GND 3 O30 GND N L=0.54 W=1.5 AD=0.75 PD=2.5 AS=1.5 PS=5
M598 O30 3 GND GND N L=0.54 W=1.5 AD=0.75 PD=2.5 AS=1.5 PS=5
M599 GND 3 O30 GND N L=0.54 W=1.5 AD=0.75 PD=2.5 AS=1.5 PS=5
M600 O30 3 GND GND N L=0.54 W=1.5 AD=0.75 PD=2.5 AS=1.5 PS=5
M601 GND 3 O30 GND N L=0.54 W=1.5 AD=0.75 PD=2.5 AS=1.35 PS=4.8
M602 O31 3 GND GND N L=0.54 W=1.5 AD=1.35 PD=4.8 AS=0.75 PS=2.5
M603 GND 3 O31 GND N L=0.54 W=1.5 AD=0.75 PD=2.5 AS=1.5 PS=5
M604 O31 3 GND GND N L=0.54 W=1.5 AD=0.75 PD=2.5 AS=1.5 PS=5
M605 GND 3 O31 GND N L=0.54 W=1.5 AD=0.75 PD=2.5 AS=1.5 PS=5
M606 O31 3 GND GND N L=0.54 W=1.5 AD=0.75 PD=2.5 AS=1.5 PS=5
M607 GND 3 O31 GND N L=0.54 W=1.5 AD=0.75 PD=2.5 AS=1.35 PS=4.8
M608 O32 3 GND GND N L=0.54 W=1.5 AD=1.35 PD=4.8 AS=0.75 PS=2.5
M609 GND 3 O32 GND N L=0.54 W=1.5 AD=0.75 PD=2.5 AS=1.5 PS=5
M610 O32 3 GND GND N L=0.54 W=1.5 AD=0.75 PD=2.5 AS=1.5 PS=5
M611 GND 3 O32 GND N L=0.54 W=1.5 AD=0.75 PD=2.5 AS=1.5 PS=5
M612 O32 3 GND GND N L=0.54 W=1.5 AD=0.75 PD=2.5 AS=1.5 PS=5
M613 GND 3 O32 GND N L=0.54 W=1.5 AD=0.75 PD=2.5 AS=1.35 PS=4.8
M614 O33 3 GND GND N L=0.54 W=1.5 AD=1.35 PD=4.8 AS=0.75 PS=2.5
M615 GND 3 O33 GND N L=0.54 W=1.5 AD=0.75 PD=2.5 AS=1.5 PS=5
M616 O33 3 GND GND N L=0.54 W=1.5 AD=0.75 PD=2.5 AS=1.5 PS=5
M617 GND 3 O33 GND N L=0.54 W=1.5 AD=0.75 PD=2.5 AS=1.5 PS=5
M618 O33 3 GND GND N L=0.54 W=1.5 AD=0.75 PD=2.5 AS=1.5 PS=5
M619 GND 3 O33 GND N L=0.54 W=1.5 AD=0.75 PD=2.5 AS=1.35 PS=4.8
M620 O34 3 GND GND N L=0.54 W=1.5 AD=1.35 PD=4.8 AS=0.75 PS=2.5
M621 GND 3 O34 GND N L=0.54 W=1.5 AD=0.75 PD=2.5 AS=1.5 PS=5
M622 O34 3 GND GND N L=0.54 W=1.5 AD=0.75 PD=2.5 AS=1.5 PS=5
M623 GND 3 O34 GND N L=0.54 W=1.5 AD=0.75 PD=2.5 AS=1.5 PS=5
M624 O34 3 GND GND N L=0.54 W=1.5 AD=0.75 PD=2.5 AS=1.5 PS=5
M625 GND 3 O34 GND N L=0.54 W=1.5 AD=0.75 PD=2.5 AS=1.35 PS=4.8
M626 O35 3 GND GND N L=0.54 W=1.5 AD=1.35 PD=4.8 AS=0.75 PS=2.5
M627 GND 3 O35 GND N L=0.54 W=1.5 AD=0.75 PD=2.5 AS=1.5 PS=5
M628 O35 3 GND GND N L=0.54 W=1.5 AD=0.75 PD=2.5 AS=1.5 PS=5
M629 GND 3 O35 GND N L=0.54 W=1.5 AD=0.75 PD=2.5 AS=1.5 PS=5
M630 O35 3 GND GND N L=0.54 W=1.5 AD=0.75 PD=2.5 AS=1.5 PS=5
M631 GND 3 O35 GND N L=0.54 W=1.5 AD=0.75 PD=2.5 AS=1.35 PS=4.8
M632 O36 3 GND GND N L=0.54 W=1.5 AD=1.35 PD=4.8 AS=0.75 PS=2.5
M633 GND 3 O36 GND N L=0.54 W=1.5 AD=0.75 PD=2.5 AS=1.5 PS=5
M634 O36 3 GND GND N L=0.54 W=1.5 AD=0.75 PD=2.5 AS=1.5 PS=5
M635 GND 3 O36 GND N L=0.54 W=1.5 AD=0.75 PD=2.5 AS=1.5 PS=5
M636 O36 3 GND GND N L=0.54 W=1.5 AD=0.75 PD=2.5 AS=1.5 PS=5
M637 GND 3 O36 GND N L=0.54 W=1.5 AD=0.75 PD=2.5 AS=1.35 PS=4.8
M638 O37 3 GND GND N L=0.54 W=1.5 AD=1.35 PD=4.8 AS=0.75 PS=2.5
M639 GND 3 O37 GND N L=0.54 W=1.5 AD=0.75 PD=2.5 AS=1.5 PS=5
M640 O37 3 GND GND N L=0.54 W=1.5 AD=0.75 PD=2.5 AS=1.5 PS=5
M641 GND 3 O37 GND N L=0.54 W=1.5 AD=0.75 PD=2.5 AS=1.5 PS=5
M642 O37 3 GND GND N L=0.54 W=1.5 AD=0.75 PD=2.5 AS=1.5 PS=5
M643 GND 3 O37 GND N L=0.54 W=1.5 AD=0.75 PD=2.5 AS=1.35 PS=4.8
M644 O38 3 GND GND N L=0.54 W=1.5 AD=1.35 PD=4.8 AS=0.75 PS=2.5
M645 GND 3 O38 GND N L=0.54 W=1.5 AD=0.75 PD=2.5 AS=1.5 PS=5
M646 O38 3 GND GND N L=0.54 W=1.5 AD=0.75 PD=2.5 AS=1.5 PS=5
M647 GND 3 O38 GND N L=0.54 W=1.5 AD=0.75 PD=2.5 AS=1.5 PS=5
M648 O38 3 GND GND N L=0.54 W=1.5 AD=0.75 PD=2.5 AS=1.5 PS=5
M649 GND 3 O38 GND N L=0.54 W=1.5 AD=0.75 PD=2.5 AS=1.35 PS=4.8
M650 O39 3 GND GND N L=0.54 W=1.5 AD=1.35 PD=4.8 AS=0.75 PS=2.5
M651 GND 3 O39 GND N L=0.54 W=1.5 AD=0.75 PD=2.5 AS=1.5 PS=5
M652 O39 3 GND GND N L=0.54 W=1.5 AD=0.75 PD=2.5 AS=1.5 PS=5
M653 GND 3 O39 GND N L=0.54 W=1.5 AD=0.75 PD=2.5 AS=1.5 PS=5
M654 O39 3 GND GND N L=0.54 W=1.5 AD=0.75 PD=2.5 AS=1.5 PS=5
M655 GND 3 O39 GND N L=0.54 W=1.5 AD=0.75 PD=2.5 AS=1.35 PS=4.8
M656 O40 3 GND GND N L=0.54 W=1.5 AD=1.35 PD=4.8 AS=0.75 PS=2.5
M657 GND 3 O40 GND N L=0.54 W=1.5 AD=0.75 PD=2.5 AS=1.5 PS=5
M658 O40 3 GND GND N L=0.54 W=1.5 AD=0.75 PD=2.5 AS=1.5 PS=5
M659 GND 3 O40 GND N L=0.54 W=1.5 AD=0.75 PD=2.5 AS=1.5 PS=5
M660 O40 3 GND GND N L=0.54 W=1.5 AD=0.75 PD=2.5 AS=1.5 PS=5
M661 GND 3 O40 GND N L=0.54 W=1.5 AD=0.75 PD=2.5 AS=1.35 PS=4.8
M662 O41 3 GND GND N L=0.54 W=1.5 AD=1.35 PD=4.8 AS=0.75 PS=2.5
M663 GND 3 O41 GND N L=0.54 W=1.5 AD=0.75 PD=2.5 AS=1.5 PS=5
M664 O41 3 GND GND N L=0.54 W=1.5 AD=0.75 PD=2.5 AS=1.5 PS=5
M665 GND 3 O41 GND N L=0.54 W=1.5 AD=0.75 PD=2.5 AS=1.5 PS=5
M666 O41 3 GND GND N L=0.54 W=1.5 AD=0.75 PD=2.5 AS=1.5 PS=5
M667 GND 3 O41 GND N L=0.54 W=1.5 AD=0.75 PD=2.5 AS=1.35 PS=4.8
M668 O42 3 GND GND N L=0.54 W=1.5 AD=1.35 PD=4.8 AS=0.75 PS=2.5
M669 GND 3 O42 GND N L=0.54 W=1.5 AD=0.75 PD=2.5 AS=1.5 PS=5
M670 O42 3 GND GND N L=0.54 W=1.5 AD=0.75 PD=2.5 AS=1.5 PS=5
M671 GND 3 O42 GND N L=0.54 W=1.5 AD=0.75 PD=2.5 AS=1.5 PS=5
M672 O42 3 GND GND N L=0.54 W=1.5 AD=0.75 PD=2.5 AS=1.5 PS=5
M673 GND 3 O42 GND N L=0.54 W=1.5 AD=0.75 PD=2.5 AS=1.35 PS=4.8
M674 O43 3 GND GND N L=0.54 W=1.5 AD=1.35 PD=4.8 AS=0.75 PS=2.5
M675 GND 3 O43 GND N L=0.54 W=1.5 AD=0.75 PD=2.5 AS=1.5 PS=5
M676 O43 3 GND GND N L=0.54 W=1.5 AD=0.75 PD=2.5 AS=1.5 PS=5
M677 GND 3 O43 GND N L=0.54 W=1.5 AD=0.75 PD=2.5 AS=1.5 PS=5
M678 O43 3 GND GND N L=0.54 W=1.5 AD=0.75 PD=2.5 AS=1.5 PS=5
M679 GND 3 O43 GND N L=0.54 W=1.5 AD=0.75 PD=2.5 AS=1.35 PS=4.8
M680 O44 3 GND GND N L=0.54 W=1.5 AD=1.35 PD=4.8 AS=0.75 PS=2.5
M681 GND 3 O44 GND N L=0.54 W=1.5 AD=0.75 PD=2.5 AS=1.5 PS=5
M682 O44 3 GND GND N L=0.54 W=1.5 AD=0.75 PD=2.5 AS=1.5 PS=5
M683 GND 3 O44 GND N L=0.54 W=1.5 AD=0.75 PD=2.5 AS=1.5 PS=5
M684 O44 3 GND GND N L=0.54 W=1.5 AD=0.75 PD=2.5 AS=1.5 PS=5
M685 GND 3 O44 GND N L=0.54 W=1.5 AD=0.75 PD=2.5 AS=1.35 PS=4.8
M686 O45 3 GND GND N L=0.54 W=1.5 AD=1.35 PD=4.8 AS=0.75 PS=2.5
M687 GND 3 O45 GND N L=0.54 W=1.5 AD=0.75 PD=2.5 AS=1.5 PS=5
M688 O45 3 GND GND N L=0.54 W=1.5 AD=0.75 PD=2.5 AS=1.5 PS=5
M689 GND 3 O45 GND N L=0.54 W=1.5 AD=0.75 PD=2.5 AS=1.5 PS=5
M690 O45 3 GND GND N L=0.54 W=1.5 AD=0.75 PD=2.5 AS=1.5 PS=5
M691 GND 3 O45 GND N L=0.54 W=1.5 AD=0.75 PD=2.5 AS=1.35 PS=4.8
M692 O46 3 GND GND N L=0.54 W=1.5 AD=1.35 PD=4.8 AS=0.75 PS=2.5
M693 GND 3 O46 GND N L=0.54 W=1.5 AD=0.75 PD=2.5 AS=1.5 PS=5
M694 O46 3 GND GND N L=0.54 W=1.5 AD=0.75 PD=2.5 AS=1.5 PS=5
M695 GND 3 O46 GND N L=0.54 W=1.5 AD=0.75 PD=2.5 AS=1.5 PS=5
M696 O46 3 GND GND N L=0.54 W=1.5 AD=0.75 PD=2.5 AS=1.5 PS=5
M697 GND 3 O46 GND N L=0.54 W=1.5 AD=0.75 PD=2.5 AS=1.35 PS=4.8
M698 O47 3 GND GND N L=0.54 W=1.5 AD=1.35 PD=4.8 AS=0.75 PS=2.5
M699 GND 3 O47 GND N L=0.54 W=1.5 AD=0.75 PD=2.5 AS=1.5 PS=5
M700 O47 3 GND GND N L=0.54 W=1.5 AD=0.75 PD=2.5 AS=1.5 PS=5
M701 GND 3 O47 GND N L=0.54 W=1.5 AD=0.75 PD=2.5 AS=1.5 PS=5
M702 O47 3 GND GND N L=0.54 W=1.5 AD=0.75 PD=2.5 AS=1.5 PS=5
M703 GND 3 O47 GND N L=0.54 W=1.5 AD=0.75 PD=2.5 AS=1.35 PS=4.8
M704 O48 3 GND GND N L=0.54 W=1.5 AD=1.35 PD=4.8 AS=0.75 PS=2.5
M705 GND 3 O48 GND N L=0.54 W=1.5 AD=0.75 PD=2.5 AS=1.5 PS=5
M706 O48 3 GND GND N L=0.54 W=1.5 AD=0.75 PD=2.5 AS=1.5 PS=5
M707 GND 3 O48 GND N L=0.54 W=1.5 AD=0.75 PD=2.5 AS=1.5 PS=5
M708 O48 3 GND GND N L=0.54 W=1.5 AD=0.75 PD=2.5 AS=1.5 PS=5
M709 GND 3 O48 GND N L=0.54 W=1.5 AD=0.75 PD=2.5 AS=1.35 PS=4.8
M710 O49 3 GND GND N L=0.54 W=1.5 AD=1.35 PD=4.8 AS=0.75 PS=2.5
M711 GND 3 O49 GND N L=0.54 W=1.5 AD=0.75 PD=2.5 AS=1.5 PS=5
M712 O49 3 GND GND N L=0.54 W=1.5 AD=0.75 PD=2.5 AS=1.5 PS=5
M713 GND 3 O49 GND N L=0.54 W=1.5 AD=0.75 PD=2.5 AS=1.5 PS=5
M714 O49 3 GND GND N L=0.54 W=1.5 AD=0.75 PD=2.5 AS=1.5 PS=5
M715 GND 3 O49 GND N L=0.54 W=1.5 AD=0.75 PD=2.5 AS=1.35 PS=4.8
M716 O50 3 GND GND N L=0.54 W=1.5 AD=1.35 PD=4.8 AS=0.75 PS=2.5
M717 GND 3 O50 GND N L=0.54 W=1.5 AD=0.75 PD=2.5 AS=1.5 PS=5
M718 O50 3 GND GND N L=0.54 W=1.5 AD=0.75 PD=2.5 AS=1.5 PS=5
M719 GND 3 O50 GND N L=0.54 W=1.5 AD=0.75 PD=2.5 AS=1.5 PS=5
M720 O50 3 GND GND N L=0.54 W=1.5 AD=0.75 PD=2.5 AS=1.5 PS=5
M721 GND 3 O50 GND N L=0.54 W=1.5 AD=0.75 PD=2.5 AS=1.35 PS=4.8
M722 O51 3 GND GND N L=0.54 W=1.5 AD=1.35 PD=4.8 AS=0.75 PS=2.5
M723 GND 3 O51 GND N L=0.54 W=1.5 AD=0.75 PD=2.5 AS=1.5 PS=5
M724 O51 3 GND GND N L=0.54 W=1.5 AD=0.75 PD=2.5 AS=1.5 PS=5
M725 GND 3 O51 GND N L=0.54 W=1.5 AD=0.75 PD=2.5 AS=1.5 PS=5
M726 O51 3 GND GND N L=0.54 W=1.5 AD=0.75 PD=2.5 AS=1.5 PS=5
M727 GND 3 O51 GND N L=0.54 W=1.5 AD=0.75 PD=2.5 AS=1.35 PS=4.8
M728 O52 3 GND GND N L=0.54 W=1.5 AD=1.35 PD=4.8 AS=0.75 PS=2.5
M729 GND 3 O52 GND N L=0.54 W=1.5 AD=0.75 PD=2.5 AS=1.5 PS=5
M730 O52 3 GND GND N L=0.54 W=1.5 AD=0.75 PD=2.5 AS=1.5 PS=5
M731 GND 3 O52 GND N L=0.54 W=1.5 AD=0.75 PD=2.5 AS=1.5 PS=5
M732 O52 3 GND GND N L=0.54 W=1.5 AD=0.75 PD=2.5 AS=1.5 PS=5
M733 GND 3 O52 GND N L=0.54 W=1.5 AD=0.75 PD=2.5 AS=1.35 PS=4.8
M734 O53 3 GND GND N L=0.54 W=1.5 AD=1.35 PD=4.8 AS=0.75 PS=2.5
M735 GND 3 O53 GND N L=0.54 W=1.5 AD=0.75 PD=2.5 AS=1.5 PS=5
M736 O53 3 GND GND N L=0.54 W=1.5 AD=0.75 PD=2.5 AS=1.5 PS=5
M737 GND 3 O53 GND N L=0.54 W=1.5 AD=0.75 PD=2.5 AS=1.5 PS=5
M738 O53 3 GND GND N L=0.54 W=1.5 AD=0.75 PD=2.5 AS=1.5 PS=5
M739 GND 3 O53 GND N L=0.54 W=1.5 AD=0.75 PD=2.5 AS=1.35 PS=4.8
M740 O54 3 GND GND N L=0.54 W=1.5 AD=1.35 PD=4.8 AS=0.75 PS=2.5
M741 GND 3 O54 GND N L=0.54 W=1.5 AD=0.75 PD=2.5 AS=1.5 PS=5
M742 O54 3 GND GND N L=0.54 W=1.5 AD=0.75 PD=2.5 AS=1.5 PS=5
M743 GND 3 O54 GND N L=0.54 W=1.5 AD=0.75 PD=2.5 AS=1.5 PS=5
M744 O54 3 GND GND N L=0.54 W=1.5 AD=0.75 PD=2.5 AS=1.5 PS=5
M745 GND 3 O54 GND N L=0.54 W=1.5 AD=0.75 PD=2.5 AS=1.35 PS=4.8
M746 O55 3 GND GND N L=0.54 W=1.5 AD=1.35 PD=4.8 AS=0.75 PS=2.5
M747 GND 3 O55 GND N L=0.54 W=1.5 AD=0.75 PD=2.5 AS=1.5 PS=5
M748 O55 3 GND GND N L=0.54 W=1.5 AD=0.75 PD=2.5 AS=1.5 PS=5
M749 GND 3 O55 GND N L=0.54 W=1.5 AD=0.75 PD=2.5 AS=1.5 PS=5
M750 O55 3 GND GND N L=0.54 W=1.5 AD=0.75 PD=2.5 AS=1.5 PS=5
M751 GND 3 O55 GND N L=0.54 W=1.5 AD=0.75 PD=2.5 AS=1.35 PS=4.8
M752 O56 3 GND GND N L=0.54 W=1.5 AD=1.35 PD=4.8 AS=0.75 PS=2.5
M753 GND 3 O56 GND N L=0.54 W=1.5 AD=0.75 PD=2.5 AS=1.5 PS=5
M754 O56 3 GND GND N L=0.54 W=1.5 AD=0.75 PD=2.5 AS=1.5 PS=5
M755 GND 3 O56 GND N L=0.54 W=1.5 AD=0.75 PD=2.5 AS=1.5 PS=5
M756 O56 3 GND GND N L=0.54 W=1.5 AD=0.75 PD=2.5 AS=1.5 PS=5
M757 GND 3 O56 GND N L=0.54 W=1.5 AD=0.75 PD=2.5 AS=1.35 PS=4.8
M758 O57 3 GND GND N L=0.54 W=1.5 AD=1.35 PD=4.8 AS=0.75 PS=2.5
M759 GND 3 O57 GND N L=0.54 W=1.5 AD=0.75 PD=2.5 AS=1.5 PS=5
M760 O57 3 GND GND N L=0.54 W=1.5 AD=0.75 PD=2.5 AS=1.5 PS=5
M761 GND 3 O57 GND N L=0.54 W=1.5 AD=0.75 PD=2.5 AS=1.5 PS=5
M762 O57 3 GND GND N L=0.54 W=1.5 AD=0.75 PD=2.5 AS=1.5 PS=5
M763 GND 3 O57 GND N L=0.54 W=1.5 AD=0.75 PD=2.5 AS=1.35 PS=4.8
M764 O58 3 GND GND N L=0.54 W=1.5 AD=1.35 PD=4.8 AS=0.75 PS=2.5
M765 GND 3 O58 GND N L=0.54 W=1.5 AD=0.75 PD=2.5 AS=1.5 PS=5
M766 O58 3 GND GND N L=0.54 W=1.5 AD=0.75 PD=2.5 AS=1.5 PS=5
M767 GND 3 O58 GND N L=0.54 W=1.5 AD=0.75 PD=2.5 AS=1.5 PS=5
M768 O58 3 GND GND N L=0.54 W=1.5 AD=0.75 PD=2.5 AS=1.5 PS=5
M769 GND 3 O58 GND N L=0.54 W=1.5 AD=0.75 PD=2.5 AS=1.35 PS=4.8
M770 O59 3 GND GND N L=0.54 W=1.5 AD=1.35 PD=4.8 AS=0.75 PS=2.5
M771 GND 3 O59 GND N L=0.54 W=1.5 AD=0.75 PD=2.5 AS=1.5 PS=5
M772 O59 3 GND GND N L=0.54 W=1.5 AD=0.75 PD=2.5 AS=1.5 PS=5
M773 GND 3 O59 GND N L=0.54 W=1.5 AD=0.75 PD=2.5 AS=1.5 PS=5
M774 O59 3 GND GND N L=0.54 W=1.5 AD=0.75 PD=2.5 AS=1.5 PS=5
M775 GND 3 O59 GND N L=0.54 W=1.5 AD=0.75 PD=2.5 AS=1.35 PS=4.8
M776 O60 3 GND GND N L=0.54 W=1.5 AD=1.35 PD=4.8 AS=0.75 PS=2.5
M777 GND 3 O60 GND N L=0.54 W=1.5 AD=0.75 PD=2.5 AS=1.5 PS=5
M778 O60 3 GND GND N L=0.54 W=1.5 AD=0.75 PD=2.5 AS=1.5 PS=5
M779 GND 3 O60 GND N L=0.54 W=1.5 AD=0.75 PD=2.5 AS=1.5 PS=5
M780 O60 3 GND GND N L=0.54 W=1.5 AD=0.75 PD=2.5 AS=1.5 PS=5
M781 GND 3 O60 GND N L=0.54 W=1.5 AD=0.75 PD=2.5 AS=1.35 PS=4.8
M782 O61 3 GND GND N L=0.54 W=1.5 AD=1.35 PD=4.8 AS=0.75 PS=2.5
M783 GND 3 O61 GND N L=0.54 W=1.5 AD=0.75 PD=2.5 AS=1.5 PS=5
M784 O61 3 GND GND N L=0.54 W=1.5 AD=0.75 PD=2.5 AS=1.5 PS=5
M785 GND 3 O61 GND N L=0.54 W=1.5 AD=0.75 PD=2.5 AS=1.5 PS=5
M786 O61 3 GND GND N L=0.54 W=1.5 AD=0.75 PD=2.5 AS=1.5 PS=5
M787 GND 3 O61 GND N L=0.54 W=1.5 AD=0.75 PD=2.5 AS=1.35 PS=4.8
M788 O62 3 GND GND N L=0.54 W=1.5 AD=1.35 PD=4.8 AS=0.75 PS=2.5
M789 GND 3 O62 GND N L=0.54 W=1.5 AD=0.75 PD=2.5 AS=1.5 PS=5
M790 O62 3 GND GND N L=0.54 W=1.5 AD=0.75 PD=2.5 AS=1.5 PS=5
M791 GND 3 O62 GND N L=0.54 W=1.5 AD=0.75 PD=2.5 AS=1.5 PS=5
M792 O62 3 GND GND N L=0.54 W=1.5 AD=0.75 PD=2.5 AS=1.5 PS=5
M793 GND 3 O62 GND N L=0.54 W=1.5 AD=0.75 PD=2.5 AS=1.35 PS=4.8
M794 O63 3 GND GND N L=0.54 W=1.5 AD=1.35 PD=4.8 AS=0.75 PS=2.5
M795 GND 3 O63 GND N L=0.54 W=1.5 AD=0.75 PD=2.5 AS=1.5 PS=5
M796 O63 3 GND GND N L=0.54 W=1.5 AD=0.75 PD=2.5 AS=1.5 PS=5
M797 GND 3 O63 GND N L=0.54 W=1.5 AD=0.75 PD=2.5 AS=1.5 PS=5
M798 O63 3 GND GND N L=0.54 W=1.5 AD=0.75 PD=2.5 AS=1.5 PS=5
M799 GND 3 O63 GND N L=0.54 W=1.5 AD=0.75 PD=2.5 AS=1.35 PS=4.8
M800 O64 3 GND GND N L=0.54 W=1.5 AD=1.35 PD=4.8 AS=0.75 PS=2.5
M801 GND 3 O64 GND N L=0.54 W=1.5 AD=0.75 PD=2.5 AS=1.5 PS=5
M802 O64 3 GND GND N L=0.54 W=1.5 AD=0.75 PD=2.5 AS=1.5 PS=5
M803 GND 3 O64 GND N L=0.54 W=1.5 AD=0.75 PD=2.5 AS=1.5 PS=5
M804 O64 3 GND GND N L=0.54 W=1.5 AD=0.75 PD=2.5 AS=1.5 PS=5
M805 GND 3 O64 GND N L=0.54 W=1.5 AD=0.75 PD=2.5 AS=1.35 PS=4.8
M806 O65 3 GND GND N L=0.54 W=1.5 AD=1.35 PD=4.8 AS=0.75 PS=2.5
M807 GND 3 O65 GND N L=0.54 W=1.5 AD=0.75 PD=2.5 AS=1.5 PS=5
M808 O65 3 GND GND N L=0.54 W=1.5 AD=0.75 PD=2.5 AS=1.5 PS=5
M809 GND 3 O65 GND N L=0.54 W=1.5 AD=0.75 PD=2.5 AS=1.5 PS=5
M810 O65 3 GND GND N L=0.54 W=1.5 AD=0.75 PD=2.5 AS=1.5 PS=5
M811 GND 3 O65 GND N L=0.54 W=1.5 AD=0.75 PD=2.5 AS=1.35 PS=4.8
M812 O66 3 GND GND N L=0.54 W=1.5 AD=1.35 PD=4.8 AS=0.75 PS=2.5
M813 GND 3 O66 GND N L=0.54 W=1.5 AD=0.75 PD=2.5 AS=1.5 PS=5
M814 O66 3 GND GND N L=0.54 W=1.5 AD=0.75 PD=2.5 AS=1.5 PS=5
M815 GND 3 O66 GND N L=0.54 W=1.5 AD=0.75 PD=2.5 AS=1.5 PS=5
M816 O66 3 GND GND N L=0.54 W=1.5 AD=0.75 PD=2.5 AS=1.5 PS=5
M817 GND 3 O66 GND N L=0.54 W=1.5 AD=0.75 PD=2.5 AS=1.35 PS=4.8
M818 O67 3 GND GND N L=0.54 W=1.5 AD=1.35 PD=4.8 AS=0.75 PS=2.5
M819 GND 3 O67 GND N L=0.54 W=1.5 AD=0.75 PD=2.5 AS=1.5 PS=5
M820 O67 3 GND GND N L=0.54 W=1.5 AD=0.75 PD=2.5 AS=1.5 PS=5
M821 GND 3 O67 GND N L=0.54 W=1.5 AD=0.75 PD=2.5 AS=1.5 PS=5
M822 O67 3 GND GND N L=0.54 W=1.5 AD=0.75 PD=2.5 AS=1.5 PS=5
M823 GND 3 O67 GND N L=0.54 W=1.5 AD=0.75 PD=2.5 AS=1.35 PS=4.8
M824 O68 3 GND GND N L=0.54 W=1.5 AD=1.35 PD=4.8 AS=0.75 PS=2.5
M825 GND 3 O68 GND N L=0.54 W=1.5 AD=0.75 PD=2.5 AS=1.5 PS=5
M826 O68 3 GND GND N L=0.54 W=1.5 AD=0.75 PD=2.5 AS=1.5 PS=5
M827 GND 3 O68 GND N L=0.54 W=1.5 AD=0.75 PD=2.5 AS=1.5 PS=5
M828 O68 3 GND GND N L=0.54 W=1.5 AD=0.75 PD=2.5 AS=1.5 PS=5
M829 GND 3 O68 GND N L=0.54 W=1.5 AD=0.75 PD=2.5 AS=1.35 PS=4.8
M830 O69 3 GND GND N L=0.54 W=1.5 AD=1.35 PD=4.8 AS=0.75 PS=2.5
M831 GND 3 O69 GND N L=0.54 W=1.5 AD=0.75 PD=2.5 AS=1.5 PS=5
M832 O69 3 GND GND N L=0.54 W=1.5 AD=0.75 PD=2.5 AS=1.5 PS=5
M833 GND 3 O69 GND N L=0.54 W=1.5 AD=0.75 PD=2.5 AS=1.5 PS=5
M834 O69 3 GND GND N L=0.54 W=1.5 AD=0.75 PD=2.5 AS=1.5 PS=5
M835 GND 3 O69 GND N L=0.54 W=1.5 AD=0.75 PD=2.5 AS=1.35 PS=4.8

*.options post probe=0
.options device scale=1u
.option scale=1u
*.global VDD GND gnd vdd

vss gnd 0 0
vdd vdd 0 1.8v
vin1 in1 0 pulse 0 1.8v 5n 0.1n 0.1n 25n 50n

*.meas tran tO69r trig v(in1) val=2.5 rise=3
*+ targ v(O69) val=2.5 rise=3
*.meas tran tO69f trig v(in1) val=2.5 fall=2
*+ targ v(O69) val=2.5 fall=2

.inc model.inc
*.lib '/home/yangfan/development/mor_clean/test_case/mod078/mod078.lib' TT
.op
.tran 0.1n 200n
.print tran V(O69) V(O67)
.save type=nodeset file=c1.nodest
.end
