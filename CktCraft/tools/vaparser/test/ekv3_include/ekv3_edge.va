// EDGE_DEVICE'S_NORMALIZATION_FACTORS
	Ispec_edge 	= Ispec * WEDGE / (Weff - WEDGE);
	Q0_edge 	= Q0 * WEDGE / (Weff - WEDGE);

// SCALING / NORMALIZING
	dgamma_edge 	= (DGAMMAEDGE * (1.0 + WLDGAMMAEDGE / WLeff) / sqrtUT);
	dphi_edge 	= DPHIEDGE * (1.0 + LDPHIEDGE / Leff) * (1.0 + WDPHIEDGE / Weff) * (1.0 + WLDPHIEDGE / WLeff) / UT;

// PINCH-OFF DELTA FOR EDGE DEVICES
	dvp_edge 	= - dgamma_edge * psi_p / (sqrt_psi_p + 0.5 * gamma_b_eff) - dphi_edge;

begin :	INVERSION_CHARGES
	`QV(qs_edge ,(vp + dvp_edge + deltapsis - vs ))
	`QV(qdp_edge,(vp + dvp_edge + deltapsis - vdp))
end

// EDGE_DEVICE'S_CURRENT
	ids_edge 	= (qs_edge * (qs_edge + 1.0) - qdp_edge * (qdp_edge + 1.0));
	IDS_edge 	= Ispec_edge * ids_edge * dits_factor;

// EDGE_DEVICE'S_CHARGE_MODEL
	psi_p_edge  		= psi_p - dgamma_edge * psi_p / (sqrt_psi_p + 0.5 * gamma_b_eff);
	sqrt_psi_p_edge 	= sqrt(`MAXA(psi_p_edge,1.0E-4,1.0E-2));
	gamma_b_chsh_edge 	= gamma_b_chsh + dgamma_edge;

	`NQ(nq_edge,psi_p_edge,sqrt_psi_p_edge,qs_edge,qdp_edge,dpd,gamma_b_chsh_edge,gamma_g2)

	qsqdp_edge	 	= qs_edge + qdp_edge;
	qs_qdp_edge 		= qs_edge - qdp_edge;
	powqs_qdp2_edge 	= qs_qdp_edge * qs_qdp_edge;
	qsqdpp1_edge 		= qsqdp_edge + 1.0;
	powqsqdpp1_2_edge 	= 1.0 / (qsqdpp1_edge * qsqdpp1_edge);

	`QX(qS_edge,psi_p_edge,nq_edge,qs_edge,qdp_edge,powqs_qdp2_edge,powqsqdpp1_2_edge)
	`QX(qD_edge,psi_p_edge,nq_edge,qdp_edge,qs_edge,powqs_qdp2_edge,powqsqdpp1_2_edge)
	`QG(qG_edge,psi_p_edge,qs_edge,qdp_edge,powqs_qdp2_edge,powqsqdpp1_2_edge,qsqdpp1_edge,v_o,gamma_g2)

	qI_edge 		= qS_edge + qD_edge;
	qB_edge 		= qG_edge - qI_edge;

	QS_edge 		=   qS_edge * Q0_edge;
	QD_edge 		=   qD_edge * Q0_edge;
	QG_edge 		= - qG_edge * Q0_edge;
	QB_edge 		= - QS_edge - QD_edge - QG_edge;

`ifdef DC_S
// SERIES RESISTANCE
	IDS_edge 		= IDS_edge / (1.0 + (rs * Ispec_edge / UT) * qs_edge + (rd * Ispec_edge / UT) * qdp_edge);
// IDS
	I(d ,s ) <+  SIGN_M * d_gt_s_flag * IDS_edge;
// CAPACITANCES
	I(b ,g ) <+  SIGN_M * ddt(QB_edge) * QON;
	I(d ,g ) <+  SIGN_M * 0.5 * ((d_gt_s_flag + 1) * ddt(QD_edge) + (1 - d_gt_s_flag) * ddt(QS_edge)) * QON;
	I(s ,g ) <+  SIGN_M * 0.5 * ((d_gt_s_flag + 1) * ddt(QS_edge) + (1 - d_gt_s_flag) * ddt(QD_edge)) * QON;
`endif

`ifdef DC
// IDS
	I(di,si) <+  SIGN_M * d_gt_s_flag * IDS_edge;
// CAPACITANCES
	I(b ,g ) <+  SIGN_M * ddt(QB_edge) * QON;
	I(di,g ) <+  SIGN_M * 0.5 * ((d_gt_s_flag + 1) * ddt(QD_edge) + (1 - d_gt_s_flag) * ddt(QS_edge)) * QON;
	I(si,g ) <+  SIGN_M * 0.5 * ((d_gt_s_flag + 1) * ddt(QS_edge) + (1 - d_gt_s_flag) * ddt(QD_edge)) * QON;
`endif

`ifdef RF_S
// IDS
	I(di,si) <+  SIGN_M * d_gt_s_flag * IDS_edge;
// CAPACITANCES
	I(bi,gi) <+  SIGN_M * ddt(QB_edge) * QON;
	I(di,gi) <+  SIGN_M * 0.5 * ((d_gt_s_flag + 1) * ddt(QD_edge) + (1 - d_gt_s_flag) * ddt(QS_edge)) * QON;
	I(si,gi) <+  SIGN_M * 0.5 * ((d_gt_s_flag + 1) * ddt(QS_edge) + (1 - d_gt_s_flag) * ddt(QD_edge)) * QON;
`endif

`ifdef RF
// IDS
	I(di,si) <+  SIGN_M * d_gt_s_flag * IDS_edge;
// CAPACITANCES
	I(bi,gi) <+  SIGN_M * ddt(QB_edge) * QON;
	I(di,gi) <+  SIGN_M * 0.5 * ((d_gt_s_flag + 1) * ddt(QD_edge) + (1 - d_gt_s_flag) * ddt(QS_edge)) * QON;
	I(si,gi) <+  SIGN_M * 0.5 * ((d_gt_s_flag + 1) * ddt(QS_edge) + (1 - d_gt_s_flag) * ddt(QD_edge)) * QON;
`endif

`ifdef NQS
	begin : EDGE_MOS_FIRST
//IV
		v1 = (d_gt_s_flag == 1) ? SIGN * V(si,bi) / UT: vdp;	v2 = SIGN * V(m1,bi) / UT;
		`QV(q1,(vp + deltapsis - v1))	i1 = q1 * q1 + q1;
		`QV(q2,(vp + deltapsis - v2))	i2 = q2 * q2 + q2;
		I(m1,si)  <+ SIGN_M * Ispec_edge * `NLS * (i1 - i2) * dits_factor;
//CV
		`NQ(nq_edge,psi_p_edge,sqrt_psi_p_edge,q1,q2,dpd,gamma_b_chsh_edge,gamma_g2)
		q1q2 	= q1 + q2;	q1_q2 = q1 - q2; powq1_q22 = q1_q2 * q1_q2; q1q2p1 = q1q2 + 1.0;	powq1q2p1_2 = 1.0 / (q1q2p1 * q1q2p1);
		`QX(qq1,psi_p_edge,nq_edge,q1,q2,powq1_q22,powq1q2p1_2)
		`QX(qq2,psi_p_edge,nq_edge,q2,q1,powq1_q22,powq1q2p1_2)
		`QG(qG_edge,psi_p_edge,q1,q2,powq1_q22,powq1q2p1_2,q1q2p1,v_o,gamma_g2)
		qB_edge = - qq1 - qq2 + qG_edge;
		I(bi,gi)    <+ SIGN_M * ddt(qB_edge  * Q0_edge / `NLS) * QON;
		I(m1,gi)  <+ SIGN_M * ddt(qq2 * Q0_edge / `NLS) * QON;
		I(si,gi)    <+ SIGN_M * ddt(qq1 * Q0_edge / `NLS) * QON;
	end
	begin
//IV
		v1 = SIGN * V(m1,bi) / UT;	v2 = SIGN * V(m2,bi) / UT;
		`QV(q1,(vp + deltapsis - v1))	i1 = q1 * q1 + q1;
		`QV(q2,(vp + deltapsis - v2))	i2 = q2 * q2 + q2;
		I(m2,m1)  <+ SIGN_M * Ispec_edge * `NLS * (i1 - i2) * dits_factor;
//CV
		`NQ(nq_edge,psi_p_edge,sqrt_psi_p_edge,q1,q2,dpd,gamma_b_chsh_edge,gamma_g2)
		q1q2 	= q1 + q2;	q1_q2 = q1 - q2; powq1_q22 = q1_q2 * q1_q2; q1q2p1 = q1q2 + 1.0;	powq1q2p1_2 = 1.0 / (q1q2p1 * q1q2p1);
		`QX(qq1,psi_p_edge,nq_edge,q1,q2,powq1_q22,powq1q2p1_2)
		`QX(qq2,psi_p_edge,nq_edge,q2,q1,powq1_q22,powq1q2p1_2)
		`QG(qG_edge,psi_p_edge,q1,q2,powq1_q22,powq1q2p1_2,q1q2p1,v_o,gamma_g2)
		qB_edge = - qq1 - qq2 + qG_edge;
		I(bi,gi)      <+ SIGN_M * ddt(qB_edge  * Q0_edge / `NLS) * QON;
		I(m2,gi)  <+ SIGN_M * ddt(qq2 * Q0_edge / `NLS) * QON;
		I(m1,gi)    <+ SIGN_M * ddt(qq1 * Q0_edge / `NLS) * QON;
	end
	begin
//IV
		v1 = SIGN * V(m2,bi) / UT;	v2 = SIGN * V(m3,bi) / UT;
		`QV(q1,(vp + deltapsis - v1))	i1 = q1 * q1 + q1;
		`QV(q2,(vp + deltapsis - v2))	i2 = q2 * q2 + q2;
		I(m3,m2)  <+ SIGN_M * Ispec_edge * `NLS * (i1 - i2) * dits_factor;
//CV
		`NQ(nq_edge,psi_p_edge,sqrt_psi_p_edge,q1,q2,dpd,gamma_b_chsh_edge,gamma_g2)
		q1q2 	= q1 + q2;	q1_q2 = q1 - q2; powq1_q22 = q1_q2 * q1_q2; q1q2p1 = q1q2 + 1.0;	powq1q2p1_2 = 1.0 / (q1q2p1 * q1q2p1);
		`QX(qq1,psi_p_edge,nq_edge,q1,q2,powq1_q22,powq1q2p1_2)
		`QX(qq2,psi_p_edge,nq_edge,q2,q1,powq1_q22,powq1q2p1_2)
		`QG(qG_edge,psi_p_edge,q1,q2,powq1_q22,powq1q2p1_2,q1q2p1,v_o,gamma_g2)
		qB_edge = - qq1 - qq2 + qG_edge;
		I(bi,gi)      <+ SIGN_M * ddt(qB_edge  * Q0_edge / `NLS) * QON;
		I(m3,gi)  <+ SIGN_M * ddt(qq2 * Q0_edge / `NLS) * QON;
		I(m2,gi)    <+ SIGN_M * ddt(qq1 * Q0_edge / `NLS) * QON;
	end
	begin
//IV
		v1 = SIGN * V(m3,bi) / UT;	v2 = SIGN * V(m4,bi) / UT;
		`QV(q1,(vp + deltapsis - v1))	i1 = q1 * q1 + q1;
		`QV(q2,(vp + deltapsis - v2))	i2 = q2 * q2 + q2;
		I(m4,m3)  <+ SIGN_M * Ispec_edge * `NLS * (i1 - i2) * dits_factor;
//CV
		`NQ(nq_edge,psi_p_edge,sqrt_psi_p_edge,q1,q2,dpd,gamma_b_chsh_edge,gamma_g2)
		q1q2 	= q1 + q2;	q1_q2 = q1 - q2; powq1_q22 = q1_q2 * q1_q2; q1q2p1 = q1q2 + 1.0;	powq1q2p1_2 = 1.0 / (q1q2p1 * q1q2p1);
		`QX(qq1,psi_p_edge,nq_edge,q1,q2,powq1_q22,powq1q2p1_2)
		`QX(qq2,psi_p_edge,nq_edge,q2,q1,powq1_q22,powq1q2p1_2)
		`QG(qG_edge,psi_p_edge,q1,q2,powq1_q22,powq1q2p1_2,q1q2p1,v_o,gamma_g2)
		qB_edge = - qq1 - qq2 + qG_edge;
		I(bi,gi)      <+ SIGN_M * ddt(qB_edge  * Q0_edge / `NLS) * QON;
		I(m4,gi)  <+ SIGN_M * ddt(qq2 * Q0_edge / `NLS) * QON;
		I(m3,gi)    <+ SIGN_M * ddt(qq1 * Q0_edge / `NLS) * QON;
	end
	begin : EDGE_MOS_LAST
//IV
		v1 = SIGN * V(m4,bi) / UT;	v2 = (d_gt_s_flag == 1) ? vdp : SIGN * V(di,bi) / UT;
		`QV(q1,(vp + deltapsis - v1))	i1 = q1 * q1 + q1;
		`QV(q2,(vp + deltapsis - v2))	i2 = q2 * q2 + q2;
		I(di,m4)  <+ SIGN_M * Ispec_edge * `NLS * (i1 - i2) * dits_factor;
//CV
		`NQ(nq_edge,psi_p_edge,sqrt_psi_p_edge,q1,q2,dpd,gamma_b_chsh_edge,gamma_g2)
		q1q2 	= q1 + q2;	q1_q2 = q1 - q2; powq1_q22 = q1_q2 * q1_q2; q1q2p1 = q1q2 + 1.0;	powq1q2p1_2 = 1.0 / (q1q2p1 * q1q2p1);
		`QX(qq1,psi_p_edge,nq_edge,q1,q2,powq1_q22,powq1q2p1_2)
		`QX(qq2,psi_p_edge,nq_edge,q2,q1,powq1_q22,powq1q2p1_2)
		`QG(qG_edge,psi_p_edge,q1,q2,powq1_q22,powq1q2p1_2,q1q2p1,v_o,gamma_g2)
		qB_edge = - qq1 - qq2 + qG_edge;
		I(bi,gi)           <+ SIGN_M * ddt(qB_edge  * Q0_edge / `NLS) * QON;
		I(di,gi)           <+ SIGN_M * ddt(qq2 * Q0_edge / `NLS) * QON;
		I(m4,gi)  <+ SIGN_M * ddt(qq1 * Q0_edge / `NLS) * QON;
	end

`endif
