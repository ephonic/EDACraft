begin : NOISE
// THERMAL NOISE (ANANDA ROY - CHRISTIAN ENZ)
	tmp 		= 1 + e_clm * qs_qdp;
	gn 		= (2 / (tmp * tmp * qsqdpp1)) * (`ONE3RD * (qs2 + qs * qdp + qdp2) + e_clm2 * i * i * 0.25 + 0.25 * (e_clm * i + 1) * qsqdp + (e_clm * i - 1) * 0.125 * e_clm2 * i * qsqdpp1 * ln(max(1.0E-24,abs((qs + 0.5 - 0.5 * e_clm * i) / (qdp + 0.5 - 0.5 * e_clm * i)))));
	thermal 	= 4.0 * `C_K * thermocrasia * Ispec * gn / UT * TH_NOI;
// FLICKER NOISE
	gmg 		= (Ispec / UT) * (qs_qdp) / nv;
	flicker 	= KF * exp(EF * ln(max(1.0E-24,abs(gmg)))) / (WeffNF * Leff * COX * inv_dqmip1);
end //  NOISE

begin : CORRELATED_NOISE
	omegaspec 	= (beta / COX) * UT / (Leff * Leff);
	if (omegaspec != 0.0)
		OMEGA 		= 1.0 / omegaspec;
	else
		OMEGA 		= 0.0;
	j 		= 1.0;
	xf 		= qs + 0.5;
	xr 		= qdp + 0.5;
	snidid 		= (4.0 * xf * xf - 3.0 * xf + 4.0 * xf * xr - 3.0 * xr + 4.0 * xr * xr) / (6.0 * (xf + xr));
	snigig 		= OMEGA * OMEGA * (16.0 * xf * xf * xf * xf + 16.0 * xr * xr * xr * xr + 80.0 * xf * xr * xr * xr + 80.0 * xf * xf * xf * xr + 168.0 * xf * xf * xr * xr - 15.0 * xf * xf * xf - 15.0 * xr * xr * xr - 75.0 * xf * xf * xr - 75.0 * xf * xr * xr) / (540.0 * nq0 * nq0 * (xf + xr) * (xf + xr) * (xf + xr) * (xf + xr) * (xf + xr));
	snibib 		= snigig * (nq0 - 1.0) * (nq0 - 1.0);
	snigid 		= (j * OMEGA / (18.0 * nq0)) * ((xf - xr) * (xf * xf + 4.0 * xf * xr + xr * xr)) / ((xf + xr) * (xf + xr) * (xf + xr));
	if ((snidid == 0.0) || (snigig == 0.0))
		c_igid 	= 0.0;
	else
		c_igid 	= j * snigid / sqrt(snidid * snigig);
	snspec 		= 4.0 * `C_K * thermocrasia * Ispec / UT;
	snidid 		= snidid * NQS_NOI;
	snigig 		= snigig * NQS_NOI;
	snigid 		= snigid * NQS_NOI;
	noise_ds1 	= snidid * (1.0 - c_igid * c_igid) * NQS_NOI;
	noise_ds2 	= c_igid * snidid * NQS_NOI;
	noise_g 	= snigig * NQS_NOI;
	noise_b 	= snibib * NQS_NOI;
	if (noise_ds1 <= 0.0) noise_ds1 = 0.0;
	if (noise_ds2 <= 0.0) noise_ds2 = 0.0;
	if (noise_g   <= 0.0) noise_g   = 0.0;
	if (noise_b   <= 0.0) noise_b   = 0.0;
end 	// CORRELATED_NOISE

begin : GATE_NOISE__SHOT_AND_FLICKER
	if (IG > 0.0)
	begin
		sig_shot 	= 2.0 * `C_QE * IG;
		sig_flicker 	= KGFN * IG * IG;
	end
	else
	begin
		sig_shot 	= 0.0;
		sig_flicker 	= 0.0;
	end
end

`ifdef DC_S
	I(d ,s ) <+  white_noise   (M * thermal,   "THERMAL NOISE IN CHANNEL");
	I(d ,s ) <+  flicker_noise (M * flicker,AF,"FLICKER NOISE IN CHANNEL");
	I(noi)   <+  V(noi);
	I(noi)   <+  white_noise(M * snspec);
	I(d ,s ) <+  white_noise(M * snspec * noise_ds1);
	I(d ,s ) <+      V(noi)  * noise_ds2;
	I(g)     <+  ddt(V(noi) * noise_g);
	I(b)     <+  flicker_noise(M * snspec * noise_b * 2.0 * `PI,-2.0);
	I(g) 	 <+  white_noise   (M * sig_shot,"GATE SHOT NOISE");
	I(g) 	 <+  flicker_noise   (M * sig_flicker,1.0,"GATE FLICKER NOISE");
`endif
`ifdef DC
	I(di,si) <+  white_noise   (M * thermal,   "THERMAL NOISE IN CHANNEL (INTERNAL NODES #2)");
	I(di,si) <+  flicker_noise (M * flicker,AF,"FLICKER NOISE IN CHANNEL (INTERNAL NODES #2)");
	I(noi)   <+  V(noi);
	I(noi)   <+  white_noise(M * snspec);
	I(di,si) <+  white_noise(M * snspec * noise_ds1);
	I(di,si) <+      V(noi)  * noise_ds2;
	I(g)     <+  ddt(V(noi) * noise_g);
	I(b)     <+  flicker_noise(M * snspec * noise_b * 2.0 * `PI,-2.0);
	I(g) 	 <+  white_noise   (M * sig_shot,"GATE SHOT NOISE");
	I(g) 	 <+  flicker_noise   (M * sig_flicker,1.0,"GATE FLICKER NOISE");
`endif
`ifdef RF_S
	I(di,si) <+  white_noise   (M * thermal,   "THERMAL NOISE IN CHANNEL (INTERNAL NODES #4)");
	I(di,si) <+  flicker_noise (M * flicker,AF,"FLICKER NOISE IN CHANNEL (INTERNAL NODES #4)");
	I(noi)   <+  V(noi);
	I(noi)   <+  white_noise(M * snspec);
	I(di,si) <+  white_noise(M * snspec * noise_ds1);
	I(di,si) <+      V(noi)  * noise_ds2;
	I(gi)    <+  ddt(V(noi) * noise_g);
	I(bi)    <+  flicker_noise(M * snspec * noise_b * 2.0 * `PI,-2.0);
	I(gi) 	 <+  white_noise   (M * sig_shot,"GATE SHOT NOISE");
	I(gi) 	 <+  flicker_noise   (M * sig_flicker,1.0,"GATE FLICKER NOISE");
`endif
`ifdef RF
	I(di,si) <+  white_noise   (M * thermal,   "THERMAL NOISE IN CHANNEL (INTERNAL NODES #6)");
	I(di,si) <+  flicker_noise (M * flicker,AF,"FLICKER NOISE IN CHANNEL (INTERNAL NODES #6)");
	I(noi)   <+  V(noi);
	I(noi)   <+  white_noise(M * snspec);
	I(di,si) <+  white_noise(M * snspec * noise_ds1);
	I(di,si) <+      V(noi)  * noise_ds2;
	I(gi)    <+  ddt(V(noi) * noise_g);
	I(bi)    <+  flicker_noise(M * snspec * noise_b * 2.0 * `PI,-2.0);
	I(gi) 	 <+  white_noise   (M * sig_shot,"GATE SHOT NOISE");
	I(gi) 	 <+  flicker_noise   (M * sig_flicker,1.0,"GATE FLICKER NOISE");
`endif
`ifdef NQS
	I(di,si) <+  white_noise   (M * thermal,   "THERMAL NOISE IN CHANNEL (INTERNAL NODES #NLS=`NLS)");
	I(di,si) <+  flicker_noise (M * flicker,AF,"FLICKER NOISE IN CHANNEL (INTERNAL NODES #NLS=`NLS)");
	I(noi)   <+  V(noi);
	I(noi)   <+  white_noise(M * snspec);
	I(di,si) <+  white_noise(M * snspec * noise_ds1);
	I(di,si) <+      V(noi)  * noise_ds2;
	I(gi)    <+  ddt(V(noi) * noise_g);
	I(bi)    <+  flicker_noise(M * snspec * noise_b * 2.0 * `PI,-2.0);
	I(gi) 	 <+  white_noise   (M * sig_shot,"GATE SHOT NOISE");
	I(gi) 	 <+  flicker_noise   (M * sig_flicker,1.0,"GATE FLICKER NOISE");
`endif
