`include "disciplines.vams"

module test(p,n);
input p;
output n;
 electrical p, n;

parameter real INFO_LEVEL = 1.0;
parameter real TT = 2.0;

analog begin : EXTRACTING_RESULTS
real Ids, gds;
Ids = TT * V(p);
gds = ddx(Ids, V(p));
end

endmodule
