* Minimal F test
V1 in 0 1.0
R1 in 0 1k
F1 out 0 V1 2.0
R2 out 0 1k
.op
.print v(out)
.end
