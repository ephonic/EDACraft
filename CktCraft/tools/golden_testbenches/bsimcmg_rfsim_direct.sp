* BSIMCMG rfsim direct drive: Vds=1.0 Vgs=1.0 Vbs=0.2
* Golden: Ids = 596 uA
VDS d 0 1.0
VGS g 0 1.0
VBS b 0 0.2

M1 d g 0 b nmos TFIN=15n L=40n NFIN=10 NRS=1 NRD=1

.model nmos bsimcmg generated=1 verbose=1
+ TOXE=1.0n TOXP=1.2n HFIN=30n
+ PHIG=4.61 NBODY=1e24 NSD=2e26
+ U0=0.04 VSAT=1.5e5 RDSW=100
+ ETA0=0.07 DSUB=0.53 DROUT=0.53
+ BG0SUB=1.12 BULKMOD=1
+ EOT=1.0n EPSROX=3.9 EPSRSUB=11.9
+ FECH=2.0 GEOMOD=1.0
+ AGIDL=5e-5 BGIDL=5e5 EGIDL=0.2
+ AGISL=5e-5 BGISL=5e5 EGISL=0.2
+ CDSC=5e-3 CDSCD=5e-3
+ DVT0=0 DVT1=0.3
+ PDIBL1=0.3 PDIBL2=0.0086
+ PCLM=0.0
+ UA=0.1 UA1=1.032e-3
+ UD=1.0 EU=0.9 ETAMOB=2.5
+ NFATOR=1.5 K1=0.001 K11=0.0 K2=0.0 K21=0.0
+ PHIBE=0.7 DELTAVSAT=1.0 MEXP=3
+ PTWG=0.0 APTWG=0.0 AT=0.007
+ RDSWMIN=0.0 RDW=50 RDWMIN=0 RSW=50 RSWMIN=0
+ PDIBLC1=0.3 PDIBLC2=0.0086
+ AIGC=0.0136 BIGC=1.71e-3 CIGC=0.075
+ AIGS=0.0136 BIGS=1.71e-3 CIGS=0.075
+ AIGD=0.0136 BIGD=1.71e-3 CIGD=0.075
+ AIGBINV=11.1e-3 BIGBINV=-1e-3 CIGBINV=6e-3 EIGBINV=1.1 NIGBINV=3
+ CGSO=0 CGDO=0
+ CJS=5e-4 CJD=5e-4
+ CJSWS=5e-10 CJSWD=5e-10
+ PBS=1.0 PBD=1.0 MJS=0.5 MJD=0.5 MJSWS=0.33 MJSWD=0.33
+ RGATEMOD=0 RGFIN=100 NQSMOD=0 RDSMOD=0 SHMOD=0 IIMOD=0

.op
.print v(d) i(VDS)
.end
