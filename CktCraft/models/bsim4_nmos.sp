* BSIM4 NMOS model card (simplified PTM 130nm, publicly available)
* Minimal parameter set sufficient for basic NMOS operation.
.model nmos bsim4va
+ level = 14
+ version = 4.8
+ tnom = 27
+ lint = 0
+ wint = 0
+ tox = 3e-9
+ vth0 = 0.358
+ k1 = 0.486
+ k2 = 0.0
+ k3 = 0.0
+ dvt0 = 1.0
+ dvt1 = 2.0
+ dvt2 = -0.032
+ u0 = 0.045
+ ua = -1e-10
+ ub = 0.0
+ vsat = 1.5e5
+ rdsw = 160
+ nfactor = 1.2
+ wint = 0.0
+ lint = 0.0
+ xl = 0.0
+ xw = 0.0
+ cgso = 0.1e-9
+ cgdo = 0.1e-9
+ cgbo = 0.0
+ cj = 1e-3
+ cjsw = 1e-10
+ mj = 0.5
+ mjsw = 0.33
+ pb = 0.88
+ pbsw = 0.88
+ mobmod = 1
+ capmod = 2
+ noimod = 1
