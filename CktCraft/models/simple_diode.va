// 极简 Shockley 二极管模型（无自热，2节点）
// I = Is * (exp(V/(n*Vt)) - 1)
// 用于验证 OSDI eval 调用通路
`include "disciplines.vams"

module simple_diode(anode, cathode);
    inout anode, cathode;
    electrical anode, cathode;
    parameter real is = 1e-15;   // 反向饱和电流
    parameter real n  = 1.0;     // 理想因子

    real vt;
    real vd;
    real id;
    real vd_lim;

    analog begin
        vt = 0.02585;
        vd = V(anode) - V(cathode);
        // tanh soft-limit with wider range (2.0V): near-linear at operating
        // point (~0.7V), smooth saturation only at high voltage.
        vd_lim = 2.0 * tanh(vd / 2.0);
        id = is * (exp(vd_lim / (n * vt)) - 1.0);
        I(anode)    <+ id;
        I(cathode)  <+ -id;
    end
endmodule
