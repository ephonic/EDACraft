// 2 节点温度相关 Shockley 二极管（中等复杂度，验证 codegen 能力边界）
// 覆盖特性: $temperature、热电压 vt=kT/q、Is 温度系数（ln/exp/pow 嵌套表达式）
// 不含内部节点/branch/ddt（那些待后续支持）
`include "disciplines.vams"

module diode_vt(anode, cathode);
    inout anode, cathode;
    electrical anode, cathode;

    parameter real is = 1e-14;    // 反向饱和电流 (tnom 下)
    parameter real n  = 1.0;      // 理想因子
    parameter real tnom = 300.0;  // 参考温度 (K)
    parameter real zetais = 3.0;  // Is 温度指数系数
    parameter real ea = 1.11;     // 激活能 (eV)

    real vd, id, vt, tdev, is_t;

    analog begin
        tdev = $temperature;
        vt = 1.380649e-23 * tdev / 1.602176634e-19;
        is_t = is * exp(ln(tdev/tnom)*zetais/n + ((tdev/tnom) - 1.0)*ea/(vt*n));
        vd = V(anode) - V(cathode);
        id = is_t * (exp(vd/(n*vt)) - 1.0);
        I(anode)   <+ id;
        I(cathode) <+ -id;
    end
endmodule
